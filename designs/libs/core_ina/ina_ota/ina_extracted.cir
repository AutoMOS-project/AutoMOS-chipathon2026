* Extracted by KLayout with GF180MCU LVS runset on : 27/08/2026 22:06

.SUBCKT ina
M$1 VDD VDD VDD VDD pfet_03v3 L=0.28U W=15U AS=10.95P AD=10.95P PS=31.46U
+ PD=31.46U
M$2 \$66 VOUTN|VOUTP \$749 VDD pfet_03v3 L=0.28U W=15U AS=11.25P AD=11.25P
+ PS=31.5U PD=31.5U
M$3 \$66 VOUTN|VOUTP \$749 VDD pfet_03v3 L=0.28U W=15U AS=11.25P AD=11.25P
+ PS=31.5U PD=31.5U
M$4 \$66 VOUTN|VOUTP \$749 VDD pfet_03v3 L=0.28U W=15U AS=11.25P AD=11.25P
+ PS=31.5U PD=31.5U
M$5 \$66 VOUTN|VOUTP \$749 VDD pfet_03v3 L=0.28U W=15U AS=11.25P AD=11.25P
+ PS=31.5U PD=31.5U
M$6 \$66 VOUTN|VOUTP \$749 VDD pfet_03v3 L=0.28U W=15U AS=11.25P AD=11.25P
+ PS=31.5U PD=31.5U
M$7 \$66 VOUTN|VOUTP \$749 VDD pfet_03v3 L=0.28U W=15U AS=11.25P AD=11.25P
+ PS=31.5U PD=31.5U
M$8 \$66 VOUTN|VOUTP \$749 VDD pfet_03v3 L=0.28U W=15U AS=11.25P AD=11.25P
+ PS=31.5U PD=31.5U
M$9 \$66 VOUTN|VOUTP \$749 VDD pfet_03v3 L=0.28U W=15U AS=11.25P AD=11.25P
+ PS=31.5U PD=31.5U
M$10 \$66 VOUTN|VOUTP \$749 VDD pfet_03v3 L=0.28U W=15U AS=11.25P AD=11.25P
+ PS=31.5U PD=31.5U
M$11 \$66 VOUTN|VOUTP \$749 VDD pfet_03v3 L=0.28U W=15U AS=11.25P AD=11.25P
+ PS=31.5U PD=31.5U
M$12 \$750 VOUTN|VOUTP \$749 VDD pfet_03v3 L=0.28U W=15U AS=11.25P AD=11.25P
+ PS=31.5U PD=31.5U
M$13 \$750 VOUTN|VOUTP \$749 VDD pfet_03v3 L=0.28U W=15U AS=11.25P AD=11.25P
+ PS=31.5U PD=31.5U
M$14 \$750 VOUTN|VOUTP \$749 VDD pfet_03v3 L=0.28U W=15U AS=11.25P AD=11.25P
+ PS=31.5U PD=31.5U
M$15 \$750 VOUTN|VOUTP \$749 VDD pfet_03v3 L=0.28U W=15U AS=11.25P AD=11.25P
+ PS=31.5U PD=31.5U
M$16 \$750 VOUTN|VOUTP \$749 VDD pfet_03v3 L=0.28U W=15U AS=11.25P AD=11.25P
+ PS=31.5U PD=31.5U
M$17 \$750 VOUTN|VOUTP \$749 VDD pfet_03v3 L=0.28U W=15U AS=11.25P AD=11.25P
+ PS=31.5U PD=31.5U
M$18 \$750 VOUTN|VOUTP \$749 VDD pfet_03v3 L=0.28U W=15U AS=11.25P AD=11.25P
+ PS=31.5U PD=31.5U
M$19 \$750 VOUTN|VOUTP \$749 VDD pfet_03v3 L=0.28U W=15U AS=11.25P AD=11.25P
+ PS=31.5U PD=31.5U
M$20 \$750 VOUTN|VOUTP \$749 VDD pfet_03v3 L=0.28U W=15U AS=11.25P AD=11.25P
+ PS=31.5U PD=31.5U
M$21 \$750 VOUTN|VOUTP \$749 VDD pfet_03v3 L=0.28U W=15U AS=11.25P AD=11.25P
+ PS=31.5U PD=31.5U
M$22 VDD VDD VDD VDD pfet_03v3 L=0.28U W=15U AS=10.95P AD=10.95P PS=31.46U
+ PD=31.46U
M$23 VDD VDD VDD VDD pfet_03v3 L=6U W=0.65U AS=0.377P AD=0.377P PS=2.46U
+ PD=2.46U
M$24 VOUTN|VOUTP \$1059 VDD VDD pfet_03v3 L=6U W=0.65U AS=0.39P AD=0.39P
+ PS=2.5U PD=2.5U
M$25 VDD VDD VDD VDD pfet_03v3 L=2U W=8U AS=4.64P AD=4.64P PS=17.16U PD=17.16U
M$26 \$749 \$1052 VDD VDD pfet_03v3 L=2U W=8U AS=4.8P AD=4.8P PS=17.2U PD=17.2U
M$27 \$1059 \$1059 VDD VDD pfet_03v3 L=6U W=0.65U AS=0.39P AD=0.39P PS=2.5U
+ PD=2.5U
M$28 VDD VDD VDD VDD pfet_03v3 L=2U W=8U AS=4.64P AD=4.64P PS=17.16U PD=17.16U
M$29 VDD VDD VDD VDD pfet_03v3 L=6U W=0.65U AS=0.377P AD=0.377P PS=2.46U
+ PD=2.46U
M$30 VOUTN|VOUTP VOUTN|VOUTP VOUTN|VOUTP VDD pfet_03v3 L=0.28U W=4U AS=3P AD=3P
+ PS=9.5U PD=9.5U
M$31 VOUTN|VOUTP VOUTN|VOUTP VOUTN|VOUTP \$752 pfet_03v3 L=0.28U W=4U AS=3P
+ AD=3P PS=9.5U PD=9.5U
M$32 VOUTN|VOUTP VOUTN|VOUTP VOUTN|VOUTP \$752 pfet_03v3 L=0.28U W=2U AS=1.5P
+ AD=1.5P PS=5.5U PD=5.5U
M$33 VOUTN|VOUTP VOUTN|VOUTP VOUTN|VOUTP VDD pfet_03v3 L=0.28U W=4U AS=3P AD=3P
+ PS=9.5U PD=9.5U
M$34 VOUTN|VOUTP VOUTN|VOUTP VOUTN|VOUTP \$752 pfet_03v3 L=0.28U W=4U AS=3P
+ AD=3P PS=9.5U PD=9.5U
M$35 VOUTN|VOUTP VOUTN|VOUTP VOUTN|VOUTP \$752 pfet_03v3 L=0.28U W=2U AS=1.5P
+ AD=1.5P PS=5.5U PD=5.5U
M$36 VOUTN|VOUTP VOUTN|VOUTP VOUTN|VOUTP \$752 pfet_03v3 L=0.28U W=4U AS=3P
+ AD=3P PS=9.5U PD=9.5U
M$37 VOUTN|VOUTP VOUTN|VOUTP VOUTN|VOUTP VDD pfet_03v3 L=0.28U W=4U AS=3P AD=3P
+ PS=9.5U PD=9.5U
M$38 VOUTN|VOUTP VOUTN|VOUTP VOUTN|VOUTP \$752 pfet_03v3 L=0.28U W=2U AS=1.5P
+ AD=1.5P PS=5.5U PD=5.5U
M$39 VOUTN|VOUTP VOUTN|VOUTP VOUTN|VOUTP \$752 pfet_03v3 L=0.28U W=4U AS=3P
+ AD=3P PS=9.5U PD=9.5U
M$40 VOUTN|VOUTP VOUTN|VOUTP VOUTN|VOUTP VDD pfet_03v3 L=0.28U W=4U AS=3P AD=3P
+ PS=9.5U PD=9.5U
M$41 VOUTN|VOUTP VOUTN|VOUTP VOUTN|VOUTP \$752 pfet_03v3 L=0.28U W=2U AS=1.5P
+ AD=1.5P PS=5.5U PD=5.5U
M$42 VDD VDD VDD VDD pfet_03v3 L=2U W=8U AS=4.64P AD=4.64P PS=17.16U PD=17.16U
M$43 \$1052 \$1052 VDD VDD pfet_03v3 L=2U W=8U AS=4.8P AD=4.8P PS=17.2U PD=17.2U
M$44 \$1064 \$1064 VDD VDD pfet_03v3 L=2U W=8U AS=4.8P AD=4.8P PS=17.2U PD=17.2U
M$45 VDD VDD VDD VDD pfet_03v3 L=2U W=8U AS=4.64P AD=4.64P PS=17.16U PD=17.16U
M$46 VDD VDD VDD VDD pfet_03v3 L=6U W=0.65U AS=0.377P AD=0.377P PS=2.46U
+ PD=2.46U
M$47 \$1067 \$1067 VDD VDD pfet_03v3 L=6U W=0.65U AS=0.39P AD=0.39P PS=2.5U
+ PD=2.5U
M$48 VOUTN|VOUTP \$1067 VDD VDD pfet_03v3 L=6U W=0.65U AS=0.39P AD=0.39P
+ PS=2.5U PD=2.5U
M$49 VDD VDD VDD VDD pfet_03v3 L=6U W=0.65U AS=0.377P AD=0.377P PS=2.46U
+ PD=2.46U
M$50 VOUTN|VOUTP VOUTN|VOUTP VOUTN|VOUTP VDD pfet_03v3 L=0.28U W=2U AS=1.5P
+ AD=1.5P PS=5.5U PD=5.5U
M$51 VOUTN|VOUTP VOUTN|VOUTP VOUTN|VOUTP VDD pfet_03v3 L=0.28U W=2U AS=1.5P
+ AD=1.5P PS=5.5U PD=5.5U
M$52 VOUTN|VOUTP VOUTN|VOUTP VOUTN|VOUTP VDD pfet_03v3 L=0.28U W=2U AS=1.5P
+ AD=1.5P PS=5.5U PD=5.5U
M$53 VOUTN|VOUTP VOUTN|VOUTP VOUTN|VOUTP VDD pfet_03v3 L=0.28U W=2U AS=1.5P
+ AD=1.5P PS=5.5U PD=5.5U
M$54 \$1320 CLK VDD VDD pfet_03v3 L=0.28U W=2U AS=1.5P AD=1.5P PS=5.5U PD=5.5U
M$55 \$1257 CLK VDD VDD pfet_03v3 L=0.28U W=2U AS=1.5P AD=1.5P PS=5.5U PD=5.5U
M$56 \$1257 \$1324 VDD VDD pfet_03v3 L=0.28U W=2U AS=1.5P AD=1.5P PS=5.5U
+ PD=5.5U
M$57 \$1321 \$1257 VDD VDD pfet_03v3 L=0.28U W=2U AS=1.5P AD=1.5P PS=5.5U
+ PD=5.5U
M$58 \$1322 \$1321 VDD VDD pfet_03v3 L=0.28U W=2U AS=1.5P AD=1.5P PS=5.5U
+ PD=5.5U
M$59 VOUTN|VOUTP \$1322 VDD VDD pfet_03v3 L=0.28U W=2U AS=1.5P AD=1.5P PS=5.5U
+ PD=5.5U
M$60 \$1259 \$1322 VDD VDD pfet_03v3 L=0.28U W=2U AS=1.5P AD=1.5P PS=5.5U
+ PD=5.5U
M$61 \$1259 \$1320 VDD VDD pfet_03v3 L=0.28U W=2U AS=1.5P AD=1.5P PS=5.5U
+ PD=5.5U
M$62 \$1323 \$1259 VDD VDD pfet_03v3 L=0.28U W=2U AS=1.5P AD=1.5P PS=5.5U
+ PD=5.5U
M$63 \$1324 \$1323 VDD VDD pfet_03v3 L=0.28U W=2U AS=1.5P AD=1.5P PS=5.5U
+ PD=5.5U
M$64 VOUTN|VOUTP \$1324 VDD VDD pfet_03v3 L=0.28U W=2U AS=1.5P AD=1.5P PS=5.5U
+ PD=5.5U
M$65 VDD VDD VDD VDD pfet_03v3 L=0.28U W=15U AS=10.95P AD=10.95P PS=31.46U
+ PD=31.46U
M$66 \$2604 VOUTN|VOUTP \$3285 VDD pfet_03v3 L=0.28U W=15U AS=11.25P AD=11.25P
+ PS=31.5U PD=31.5U
M$67 \$2604 VOUTN|VOUTP \$3285 VDD pfet_03v3 L=0.28U W=15U AS=11.25P AD=11.25P
+ PS=31.5U PD=31.5U
M$68 \$2604 VOUTN|VOUTP \$3285 VDD pfet_03v3 L=0.28U W=15U AS=11.25P AD=11.25P
+ PS=31.5U PD=31.5U
M$69 \$2604 VOUTN|VOUTP \$3285 VDD pfet_03v3 L=0.28U W=15U AS=11.25P AD=11.25P
+ PS=31.5U PD=31.5U
M$70 \$2604 VOUTN|VOUTP \$3285 VDD pfet_03v3 L=0.28U W=15U AS=11.25P AD=11.25P
+ PS=31.5U PD=31.5U
M$71 \$2604 VOUTN|VOUTP \$3285 VDD pfet_03v3 L=0.28U W=15U AS=11.25P AD=11.25P
+ PS=31.5U PD=31.5U
M$72 \$2604 VOUTN|VOUTP \$3285 VDD pfet_03v3 L=0.28U W=15U AS=11.25P AD=11.25P
+ PS=31.5U PD=31.5U
M$73 \$2604 VOUTN|VOUTP \$3285 VDD pfet_03v3 L=0.28U W=15U AS=11.25P AD=11.25P
+ PS=31.5U PD=31.5U
M$74 \$2604 VOUTN|VOUTP \$3285 VDD pfet_03v3 L=0.28U W=15U AS=11.25P AD=11.25P
+ PS=31.5U PD=31.5U
M$75 \$2604 VOUTN|VOUTP \$3285 VDD pfet_03v3 L=0.28U W=15U AS=11.25P AD=11.25P
+ PS=31.5U PD=31.5U
M$76 \$3286 VOUTN|VOUTP \$3285 VDD pfet_03v3 L=0.28U W=15U AS=11.25P AD=11.25P
+ PS=31.5U PD=31.5U
M$77 \$3286 VOUTN|VOUTP \$3285 VDD pfet_03v3 L=0.28U W=15U AS=11.25P AD=11.25P
+ PS=31.5U PD=31.5U
M$78 \$3286 VOUTN|VOUTP \$3285 VDD pfet_03v3 L=0.28U W=15U AS=11.25P AD=11.25P
+ PS=31.5U PD=31.5U
M$79 \$3286 VOUTN|VOUTP \$3285 VDD pfet_03v3 L=0.28U W=15U AS=11.25P AD=11.25P
+ PS=31.5U PD=31.5U
M$80 \$3286 VOUTN|VOUTP \$3285 VDD pfet_03v3 L=0.28U W=15U AS=11.25P AD=11.25P
+ PS=31.5U PD=31.5U
M$81 \$3286 VOUTN|VOUTP \$3285 VDD pfet_03v3 L=0.28U W=15U AS=11.25P AD=11.25P
+ PS=31.5U PD=31.5U
M$82 \$3286 VOUTN|VOUTP \$3285 VDD pfet_03v3 L=0.28U W=15U AS=11.25P AD=11.25P
+ PS=31.5U PD=31.5U
M$83 \$3286 VOUTN|VOUTP \$3285 VDD pfet_03v3 L=0.28U W=15U AS=11.25P AD=11.25P
+ PS=31.5U PD=31.5U
M$84 \$3286 VOUTN|VOUTP \$3285 VDD pfet_03v3 L=0.28U W=15U AS=11.25P AD=11.25P
+ PS=31.5U PD=31.5U
M$85 \$3286 VOUTN|VOUTP \$3285 VDD pfet_03v3 L=0.28U W=15U AS=11.25P AD=11.25P
+ PS=31.5U PD=31.5U
M$86 VDD VDD VDD VDD pfet_03v3 L=0.28U W=15U AS=10.95P AD=10.95P PS=31.46U
+ PD=31.46U
M$87 VDD VDD VDD VDD pfet_03v3 L=6U W=0.65U AS=0.377P AD=0.377P PS=2.46U
+ PD=2.46U
M$88 VOUTN|VOUTP \$3594 VDD VDD pfet_03v3 L=6U W=0.65U AS=0.39P AD=0.39P
+ PS=2.5U PD=2.5U
M$89 VDD VDD VDD VDD pfet_03v3 L=2U W=8U AS=4.64P AD=4.64P PS=17.16U PD=17.16U
M$90 \$3285 \$3587 VDD VDD pfet_03v3 L=2U W=8U AS=4.8P AD=4.8P PS=17.2U PD=17.2U
M$91 \$3594 \$3594 VDD VDD pfet_03v3 L=6U W=0.65U AS=0.39P AD=0.39P PS=2.5U
+ PD=2.5U
M$92 VDD VDD VDD VDD pfet_03v3 L=2U W=8U AS=4.64P AD=4.64P PS=17.16U PD=17.16U
M$93 VDD VDD VDD VDD pfet_03v3 L=6U W=0.65U AS=0.377P AD=0.377P PS=2.46U
+ PD=2.46U
M$94 VOUTN|VOUTP VOUTN|VOUTP VOUTN|VOUTP VDD pfet_03v3 L=0.28U W=4U AS=3P AD=3P
+ PS=9.5U PD=9.5U
M$95 VOUTN|VOUTP VOUTN|VOUTP VOUTN|VOUTP \$3288 pfet_03v3 L=0.28U W=4U AS=3P
+ AD=3P PS=9.5U PD=9.5U
M$96 VOUTN|VOUTP VOUTN|VOUTP VOUTN|VOUTP \$3288 pfet_03v3 L=0.28U W=2U AS=1.5P
+ AD=1.5P PS=5.5U PD=5.5U
M$97 VOUTN|VOUTP VOUTN|VOUTP VOUTN|VOUTP VDD pfet_03v3 L=0.28U W=4U AS=3P AD=3P
+ PS=9.5U PD=9.5U
M$98 VOUTN|VOUTP VOUTN|VOUTP VOUTN|VOUTP \$3288 pfet_03v3 L=0.28U W=4U AS=3P
+ AD=3P PS=9.5U PD=9.5U
M$99 VOUTN|VOUTP VOUTN|VOUTP VOUTN|VOUTP \$3288 pfet_03v3 L=0.28U W=2U AS=1.5P
+ AD=1.5P PS=5.5U PD=5.5U
M$100 VOUTN|VOUTP VOUTN|VOUTP VOUTN|VOUTP \$3288 pfet_03v3 L=0.28U W=4U AS=3P
+ AD=3P PS=9.5U PD=9.5U
M$101 VOUTN|VOUTP VOUTN|VOUTP VOUTN|VOUTP VDD pfet_03v3 L=0.28U W=4U AS=3P
+ AD=3P PS=9.5U PD=9.5U
M$102 VOUTN|VOUTP VOUTN|VOUTP VOUTN|VOUTP \$3288 pfet_03v3 L=0.28U W=2U AS=1.5P
+ AD=1.5P PS=5.5U PD=5.5U
M$103 VOUTN|VOUTP VOUTN|VOUTP VOUTN|VOUTP \$3288 pfet_03v3 L=0.28U W=4U AS=3P
+ AD=3P PS=9.5U PD=9.5U
M$104 VOUTN|VOUTP VOUTN|VOUTP VOUTN|VOUTP VDD pfet_03v3 L=0.28U W=4U AS=3P
+ AD=3P PS=9.5U PD=9.5U
M$105 VOUTN|VOUTP VOUTN|VOUTP VOUTN|VOUTP \$3288 pfet_03v3 L=0.28U W=2U AS=1.5P
+ AD=1.5P PS=5.5U PD=5.5U
M$106 VDD VDD VDD VDD pfet_03v3 L=2U W=8U AS=4.64P AD=4.64P PS=17.16U PD=17.16U
M$107 \$3587 \$3587 VDD VDD pfet_03v3 L=2U W=8U AS=4.8P AD=4.8P PS=17.2U
+ PD=17.2U
M$108 \$3599 \$3599 VDD VDD pfet_03v3 L=2U W=8U AS=4.8P AD=4.8P PS=17.2U
+ PD=17.2U
M$109 VDD VDD VDD VDD pfet_03v3 L=2U W=8U AS=4.64P AD=4.64P PS=17.16U PD=17.16U
M$110 VDD VDD VDD VDD pfet_03v3 L=6U W=0.65U AS=0.377P AD=0.377P PS=2.46U
+ PD=2.46U
M$111 \$3602 \$3602 VDD VDD pfet_03v3 L=6U W=0.65U AS=0.39P AD=0.39P PS=2.5U
+ PD=2.5U
M$112 VOUTN|VOUTP \$3602 VDD VDD pfet_03v3 L=6U W=0.65U AS=0.39P AD=0.39P
+ PS=2.5U PD=2.5U
M$113 VDD VDD VDD VDD pfet_03v3 L=6U W=0.65U AS=0.377P AD=0.377P PS=2.46U
+ PD=2.46U
M$114 VOUTN|VOUTP VOUTN|VOUTP VOUTN|VOUTP VDD pfet_03v3 L=0.28U W=2U AS=1.5P
+ AD=1.5P PS=5.5U PD=5.5U
M$115 VOUTN|VOUTP VOUTN|VOUTP VOUTN|VOUTP VDD pfet_03v3 L=0.28U W=2U AS=1.5P
+ AD=1.5P PS=5.5U PD=5.5U
M$116 VOUTN|VOUTP VOUTN|VOUTP VOUTN|VOUTP VDD pfet_03v3 L=0.28U W=2U AS=1.5P
+ AD=1.5P PS=5.5U PD=5.5U
M$117 VOUTN|VOUTP VOUTN|VOUTP VOUTN|VOUTP VDD pfet_03v3 L=0.28U W=2U AS=1.5P
+ AD=1.5P PS=5.5U PD=5.5U
M$118 VSS VSS VSS VSS nfet_03v3 L=6U W=1.8U AS=1.044P AD=1.044P PS=4.76U
+ PD=4.76U
M$119 \$66 \$66 VSS VSS nfet_03v3 L=6U W=1.8U AS=1.08P AD=1.08P PS=4.8U PD=4.8U
M$120 \$1059 \$66 VSS VSS nfet_03v3 L=6U W=1.8U AS=1.08P AD=1.08P PS=4.8U
+ PD=4.8U
M$121 VOUTN|VOUTP \$66 VSS VSS nfet_03v3 L=6U W=1.8U AS=1.08P AD=1.08P PS=4.8U
+ PD=4.8U
M$122 VSS VSS VSS VSS nfet_03v3 L=6U W=1.8U AS=1.044P AD=1.044P PS=4.76U
+ PD=4.76U
M$123 VSS VSS VSS VSS nfet_03v3 L=6U W=1.8U AS=1.044P AD=1.044P PS=4.76U
+ PD=4.76U
M$124 VOUTN|VOUTP \$750 VSS VSS nfet_03v3 L=6U W=1.8U AS=1.08P AD=1.08P PS=4.8U
+ PD=4.8U
M$125 \$1067 \$750 VSS VSS nfet_03v3 L=6U W=1.8U AS=1.08P AD=1.08P PS=4.8U
+ PD=4.8U
M$126 \$750 \$750 VSS VSS nfet_03v3 L=6U W=1.8U AS=1.08P AD=1.08P PS=4.8U
+ PD=4.8U
M$127 VSS VSS VSS VSS nfet_03v3 L=6U W=1.8U AS=1.044P AD=1.044P PS=4.76U
+ PD=4.76U
M$128 VOUTN|VOUTP VOUTN|VOUTP VOUTN|VOUTP VSS nfet_03v3 L=0.28U W=2U AS=1.5P
+ AD=1.5P PS=5.5U PD=5.5U
M$129 VOUTN|VOUTP VOUTN|VOUTP VOUTN|VOUTP VSS nfet_03v3 L=0.28U W=2U AS=1.5P
+ AD=1.5P PS=5.5U PD=5.5U
M$130 VOUTN|VOUTP VOUTN|VOUTP VOUTN|VOUTP VSS nfet_03v3 L=0.28U W=2U AS=1.5P
+ AD=1.5P PS=5.5U PD=5.5U
M$131 VOUTN|VOUTP VOUTN|VOUTP VOUTN|VOUTP VSS nfet_03v3 L=0.28U W=2U AS=1.5P
+ AD=1.5P PS=5.5U PD=5.5U
M$132 VOUTN|VOUTP VOUTN|VOUTP VOUTN|VOUTP VSS nfet_03v3 L=0.28U W=1U AS=0.75P
+ AD=0.75P PS=3.5U PD=3.5U
M$133 VOUTN|VOUTP VOUTN|VOUTP VOUTN|VOUTP VSS nfet_03v3 L=0.28U W=1U AS=0.75P
+ AD=0.75P PS=3.5U PD=3.5U
M$134 VOUTN|VOUTP VOUTN|VOUTP VOUTN|VOUTP VSS nfet_03v3 L=0.28U W=1U AS=0.75P
+ AD=0.75P PS=3.5U PD=3.5U
M$135 VOUTN|VOUTP VOUTN|VOUTP VOUTN|VOUTP VSS nfet_03v3 L=0.28U W=1U AS=0.75P
+ AD=0.75P PS=3.5U PD=3.5U
M$136 VSS VSS VSS VSS nfet_03v3 L=2U W=1.6U AS=0.928P AD=0.928P PS=4.36U
+ PD=4.36U
M$137 VSS VSS VSS VSS nfet_03v3 L=2U W=3.2U AS=1.856P AD=1.856P PS=7.56U
+ PD=7.56U
M$138 \$759 IB VSS VSS nfet_03v3 L=2U W=3.2U AS=1.92P AD=1.92P PS=7.6U PD=7.6U
M$139 \$1052 VOUTN|VOUTP \$1051 VSS nfet_03v3 L=2U W=1.6U AS=0.96P AD=0.96P
+ PS=4.4U PD=4.4U
M$140 \$1064 VCM \$1051 VSS nfet_03v3 L=2U W=1.6U AS=0.96P AD=0.96P PS=4.4U
+ PD=4.4U
M$141 \$1051 IB VSS VSS nfet_03v3 L=2U W=3.2U AS=1.92P AD=1.92P PS=7.6U PD=7.6U
M$142 VSS VSS VSS VSS nfet_03v3 L=2U W=3.2U AS=1.856P AD=1.856P PS=7.56U
+ PD=7.56U
M$143 VSS VSS VSS VSS nfet_03v3 L=2U W=1.6U AS=0.928P AD=0.928P PS=4.36U
+ PD=4.36U
M$144 VSS VSS VSS VSS nfet_03v3 L=2U W=1.6U AS=0.928P AD=0.928P PS=4.36U
+ PD=4.36U
M$145 \$1052 VOUTN|VOUTP \$759 VSS nfet_03v3 L=2U W=1.6U AS=0.96P AD=0.96P
+ PS=4.4U PD=4.4U
M$146 \$1064 VCM \$759 VSS nfet_03v3 L=2U W=1.6U AS=0.96P AD=0.96P PS=4.4U
+ PD=4.4U
M$147 VSS VSS VSS VSS nfet_03v3 L=2U W=1.6U AS=0.928P AD=0.928P PS=4.36U
+ PD=4.36U
M$148 VOUTN|VOUTP VOUTN|VOUTP VOUTN|VOUTP VSS nfet_03v3 L=0.28U W=2U AS=1.5P
+ AD=1.5P PS=5.5U PD=5.5U
M$149 VOUTN|VOUTP VOUTN|VOUTP VOUTN|VOUTP VSS nfet_03v3 L=0.28U W=2U AS=1.5P
+ AD=1.5P PS=5.5U PD=5.5U
M$150 VOUTN|VOUTP VOUTN|VOUTP VOUTN|VOUTP VSS nfet_03v3 L=0.28U W=2U AS=1.5P
+ AD=1.5P PS=5.5U PD=5.5U
M$151 VOUTN|VOUTP VOUTN|VOUTP VOUTN|VOUTP VSS nfet_03v3 L=0.28U W=2U AS=1.5P
+ AD=1.5P PS=5.5U PD=5.5U
M$152 VOUTN|VOUTP VOUTN|VOUTP VOUTN|VOUTP VSS nfet_03v3 L=0.28U W=1U AS=0.75P
+ AD=0.75P PS=3.5U PD=3.5U
M$153 VOUTN|VOUTP VOUTN|VOUTP VOUTN|VOUTP VSS nfet_03v3 L=0.28U W=1U AS=0.75P
+ AD=0.75P PS=3.5U PD=3.5U
M$154 VOUTN|VOUTP VOUTN|VOUTP VOUTN|VOUTP VSS nfet_03v3 L=0.28U W=1U AS=0.75P
+ AD=0.75P PS=3.5U PD=3.5U
M$155 VOUTN|VOUTP VOUTN|VOUTP VOUTN|VOUTP VSS nfet_03v3 L=0.28U W=1U AS=0.75P
+ AD=0.75P PS=3.5U PD=3.5U
M$156 \$1257 CLK \$1256 VSS nfet_03v3 L=0.28U W=2U AS=1.5P AD=1.5P PS=5.5U
+ PD=5.5U
M$157 \$1256 \$1324 VSS VSS nfet_03v3 L=0.28U W=2U AS=1.5P AD=1.5P PS=5.5U
+ PD=5.5U
M$158 \$1259 \$1322 \$1258 VSS nfet_03v3 L=0.28U W=2U AS=1.5P AD=1.5P PS=5.5U
+ PD=5.5U
M$159 \$1258 \$1320 VSS VSS nfet_03v3 L=0.28U W=2U AS=1.5P AD=1.5P PS=5.5U
+ PD=5.5U
M$160 \$1320 CLK VSS VSS nfet_03v3 L=0.28U W=1U AS=0.75P AD=0.75P PS=3.5U
+ PD=3.5U
M$161 \$1321 \$1257 VSS VSS nfet_03v3 L=0.28U W=1U AS=0.75P AD=0.75P PS=3.5U
+ PD=3.5U
M$162 \$1322 \$1321 VSS VSS nfet_03v3 L=0.28U W=1U AS=0.75P AD=0.75P PS=3.5U
+ PD=3.5U
M$163 VOUTN|VOUTP \$1322 VSS VSS nfet_03v3 L=0.28U W=1U AS=0.75P AD=0.75P
+ PS=3.5U PD=3.5U
M$164 \$1323 \$1259 VSS VSS nfet_03v3 L=0.28U W=1U AS=0.75P AD=0.75P PS=3.5U
+ PD=3.5U
M$165 \$1324 \$1323 VSS VSS nfet_03v3 L=0.28U W=1U AS=0.75P AD=0.75P PS=3.5U
+ PD=3.5U
M$166 VOUTN|VOUTP \$1324 VSS VSS nfet_03v3 L=0.28U W=1U AS=0.75P AD=0.75P
+ PS=3.5U PD=3.5U
M$167 VSS VSS VSS VSS nfet_03v3 L=6U W=1.8U AS=1.044P AD=1.044P PS=4.76U
+ PD=4.76U
M$168 VSS VSS VSS VSS nfet_03v3 L=6U W=1.8U AS=1.044P AD=1.044P PS=4.76U
+ PD=4.76U
M$169 \$2604 \$2604 VSS VSS nfet_03v3 L=6U W=1.8U AS=1.08P AD=1.08P PS=4.8U
+ PD=4.8U
M$170 VOUTN|VOUTP \$3286 VSS VSS nfet_03v3 L=6U W=1.8U AS=1.08P AD=1.08P
+ PS=4.8U PD=4.8U
M$171 \$3602 \$3286 VSS VSS nfet_03v3 L=6U W=1.8U AS=1.08P AD=1.08P PS=4.8U
+ PD=4.8U
M$172 \$3594 \$2604 VSS VSS nfet_03v3 L=6U W=1.8U AS=1.08P AD=1.08P PS=4.8U
+ PD=4.8U
M$173 \$3286 \$3286 VSS VSS nfet_03v3 L=6U W=1.8U AS=1.08P AD=1.08P PS=4.8U
+ PD=4.8U
M$174 VOUTN|VOUTP \$2604 VSS VSS nfet_03v3 L=6U W=1.8U AS=1.08P AD=1.08P
+ PS=4.8U PD=4.8U
M$175 VSS VSS VSS VSS nfet_03v3 L=6U W=1.8U AS=1.044P AD=1.044P PS=4.76U
+ PD=4.76U
M$176 VSS VSS VSS VSS nfet_03v3 L=6U W=1.8U AS=1.044P AD=1.044P PS=4.76U
+ PD=4.76U
M$177 VSS VSS VSS VSS nfet_03v3 L=2U W=3.2U AS=1.856P AD=1.856P PS=7.56U
+ PD=7.56U
M$178 IB IB VSS VSS nfet_03v3 L=2U W=3.2U AS=1.92P AD=1.92P PS=7.6U PD=7.6U
M$179 VSS VSS VSS VSS nfet_03v3 L=2U W=3.2U AS=1.856P AD=1.856P PS=7.56U
+ PD=7.56U
M$180 VOUTN|VOUTP VOUTN|VOUTP VOUTN|VOUTP VSS nfet_03v3 L=0.28U W=2U AS=1.5P
+ AD=1.5P PS=5.5U PD=5.5U
M$181 VOUTN|VOUTP VOUTN|VOUTP VOUTN|VOUTP VSS nfet_03v3 L=0.28U W=2U AS=1.5P
+ AD=1.5P PS=5.5U PD=5.5U
M$182 VOUTN|VOUTP VOUTN|VOUTP VOUTN|VOUTP VSS nfet_03v3 L=0.28U W=2U AS=1.5P
+ AD=1.5P PS=5.5U PD=5.5U
M$183 VOUTN|VOUTP VOUTN|VOUTP VOUTN|VOUTP VSS nfet_03v3 L=0.28U W=2U AS=1.5P
+ AD=1.5P PS=5.5U PD=5.5U
M$184 VOUTN|VOUTP VOUTN|VOUTP VOUTN|VOUTP VSS nfet_03v3 L=0.28U W=1U AS=0.75P
+ AD=0.75P PS=3.5U PD=3.5U
M$185 VOUTN|VOUTP VOUTN|VOUTP VOUTN|VOUTP VSS nfet_03v3 L=0.28U W=1U AS=0.75P
+ AD=0.75P PS=3.5U PD=3.5U
M$186 VOUTN|VOUTP VOUTN|VOUTP VOUTN|VOUTP VSS nfet_03v3 L=0.28U W=1U AS=0.75P
+ AD=0.75P PS=3.5U PD=3.5U
M$187 VOUTN|VOUTP VOUTN|VOUTP VOUTN|VOUTP VSS nfet_03v3 L=0.28U W=1U AS=0.75P
+ AD=0.75P PS=3.5U PD=3.5U
M$188 VSS VSS VSS VSS nfet_03v3 L=2U W=1.6U AS=0.928P AD=0.928P PS=4.36U
+ PD=4.36U
M$189 VSS VSS VSS VSS nfet_03v3 L=2U W=3.2U AS=1.856P AD=1.856P PS=7.56U
+ PD=7.56U
M$190 \$3587 VOUTN|VOUTP \$3586 VSS nfet_03v3 L=2U W=1.6U AS=0.96P AD=0.96P
+ PS=4.4U PD=4.4U
M$191 \$3295 IB VSS VSS nfet_03v3 L=2U W=3.2U AS=1.92P AD=1.92P PS=7.6U PD=7.6U
M$192 \$3599 VCM \$3586 VSS nfet_03v3 L=2U W=1.6U AS=0.96P AD=0.96P PS=4.4U
+ PD=4.4U
M$193 \$3586 IB VSS VSS nfet_03v3 L=2U W=3.2U AS=1.92P AD=1.92P PS=7.6U PD=7.6U
M$194 VSS VSS VSS VSS nfet_03v3 L=2U W=3.2U AS=1.856P AD=1.856P PS=7.56U
+ PD=7.56U
M$195 VSS VSS VSS VSS nfet_03v3 L=2U W=1.6U AS=0.928P AD=0.928P PS=4.36U
+ PD=4.36U
M$196 VSS VSS VSS VSS nfet_03v3 L=2U W=1.6U AS=0.928P AD=0.928P PS=4.36U
+ PD=4.36U
M$197 \$3587 VOUTN|VOUTP \$3295 VSS nfet_03v3 L=2U W=1.6U AS=0.96P AD=0.96P
+ PS=4.4U PD=4.4U
M$198 \$3599 VCM \$3295 VSS nfet_03v3 L=2U W=1.6U AS=0.96P AD=0.96P PS=4.4U
+ PD=4.4U
M$199 VSS VSS VSS VSS nfet_03v3 L=2U W=1.6U AS=0.928P AD=0.928P PS=4.36U
+ PD=4.36U
M$200 VOUTN|VOUTP VOUTN|VOUTP VOUTN|VOUTP VSS nfet_03v3 L=0.28U W=2U AS=1.5P
+ AD=1.5P PS=5.5U PD=5.5U
M$201 VOUTN|VOUTP VOUTN|VOUTP VOUTN|VOUTP VSS nfet_03v3 L=0.28U W=2U AS=1.5P
+ AD=1.5P PS=5.5U PD=5.5U
M$202 VOUTN|VOUTP VOUTN|VOUTP VOUTN|VOUTP VSS nfet_03v3 L=0.28U W=2U AS=1.5P
+ AD=1.5P PS=5.5U PD=5.5U
M$203 VOUTN|VOUTP VOUTN|VOUTP VOUTN|VOUTP VSS nfet_03v3 L=0.28U W=2U AS=1.5P
+ AD=1.5P PS=5.5U PD=5.5U
M$204 VOUTN|VOUTP VOUTN|VOUTP VOUTN|VOUTP VSS nfet_03v3 L=0.28U W=1U AS=0.75P
+ AD=0.75P PS=3.5U PD=3.5U
M$205 VOUTN|VOUTP VOUTN|VOUTP VOUTN|VOUTP VSS nfet_03v3 L=0.28U W=1U AS=0.75P
+ AD=0.75P PS=3.5U PD=3.5U
M$206 VOUTN|VOUTP VOUTN|VOUTP VOUTN|VOUTP VSS nfet_03v3 L=0.28U W=1U AS=0.75P
+ AD=0.75P PS=3.5U PD=3.5U
M$207 VOUTN|VOUTP VOUTN|VOUTP VOUTN|VOUTP VSS nfet_03v3 L=0.28U W=1U AS=0.75P
+ AD=0.75P PS=3.5U PD=3.5U
M$208 \$430 VG VG VG nfet_03v3 L=5U W=0.5U AS=0.3P AD=0.3P PS=2.2U PD=2.2U
M$209 VOUTN|VOUTP \$248 \$248 \$248 nfet_03v3 L=12U W=0.5U AS=0.3P AD=0.3P
+ PS=2.2U PD=2.2U
M$210 VOUTN|VOUTP VG VG VG nfet_03v3 L=5U W=0.5U AS=0.3P AD=0.3P PS=2.2U PD=2.2U
M$211 \$430 \$248 \$248 \$248 nfet_03v3 L=12U W=0.5U AS=0.3P AD=0.3P PS=2.2U
+ PD=2.2U
M$212 \$1054 VG VG VG nfet_03v3 L=5U W=0.5U AS=0.3P AD=0.3P PS=2.2U PD=2.2U
M$213 VOUTN|VOUTP \$1053 \$1053 \$1053 nfet_03v3 L=12U W=0.5U AS=0.3P AD=0.3P
+ PS=2.2U PD=2.2U
M$214 VOUTN|VOUTP VG VG VG nfet_03v3 L=5U W=0.5U AS=0.3P AD=0.3P PS=2.2U PD=2.2U
M$215 \$1054 \$1053 \$1053 \$1053 nfet_03v3 L=12U W=0.5U AS=0.3P AD=0.3P
+ PS=2.2U PD=2.2U
M$216 \$2967 VG VG VG nfet_03v3 L=5U W=0.5U AS=0.3P AD=0.3P PS=2.2U PD=2.2U
M$217 VOUTN|VOUTP \$2785 \$2785 \$2785 nfet_03v3 L=12U W=0.5U AS=0.3P AD=0.3P
+ PS=2.2U PD=2.2U
M$218 VOUTN|VOUTP VG VG VG nfet_03v3 L=5U W=0.5U AS=0.3P AD=0.3P PS=2.2U PD=2.2U
M$219 \$2967 \$2785 \$2785 \$2785 nfet_03v3 L=12U W=0.5U AS=0.3P AD=0.3P
+ PS=2.2U PD=2.2U
M$220 \$3589 VG VG VG nfet_03v3 L=5U W=0.5U AS=0.3P AD=0.3P PS=2.2U PD=2.2U
M$221 VOUTN|VOUTP \$3588 \$3588 \$3588 nfet_03v3 L=12U W=0.5U AS=0.3P AD=0.3P
+ PS=2.2U PD=2.2U
M$222 VOUTN|VOUTP VG VG VG nfet_03v3 L=5U W=0.5U AS=0.3P AD=0.3P PS=2.2U PD=2.2U
M$223 \$3589 \$3588 \$3588 \$3588 nfet_03v3 L=12U W=0.5U AS=0.3P AD=0.3P
+ PS=2.2U PD=2.2U
C$224 VOUTN|VOUTP VOUTN|VOUTP 2e-13 cap_mim_2f0fF A=100P P=40U
C$225 VOUTN|VOUTP VOUTN|VOUTP 2e-13 cap_mim_2f0fF A=100P P=40U
C$226 VOUTN|VOUTP VINP 8e-13 cap_mim_2f0fF A=400P P=80U
C$227 VOUTN|VOUTP VOUTN|VOUTP 2e-13 cap_mim_2f0fF A=100P P=40U
C$228 VOUTN|VOUTP VOUTN|VOUTP 2e-13 cap_mim_2f0fF A=100P P=40U
C$229 VOUTN|VOUTP VOUTN|VOUTP 2e-13 cap_mim_2f0fF A=100P P=40U
C$230 VOUTN|VOUTP VINN 8e-13 cap_mim_2f0fF A=400P P=80U
C$231 VOUTN|VOUTP VOUTN|VOUTP 2e-13 cap_mim_2f0fF A=100P P=40U
C$232 VOUTN|VOUTP VINN 8e-13 cap_mim_2f0fF A=400P P=80U
C$233 VOUTN|VOUTP VOUTN|VOUTP 2e-13 cap_mim_2f0fF A=100P P=40U
C$234 VOUTN|VOUTP VOUTN|VOUTP 2e-13 cap_mim_2f0fF A=100P P=40U
C$235 VOUTN|VOUTP VOUTN|VOUTP 2e-13 cap_mim_2f0fF A=100P P=40U
C$236 VOUTN|VOUTP VOUTN|VOUTP 2e-13 cap_mim_2f0fF A=100P P=40U
C$237 VOUTN|VOUTP VINN 8e-13 cap_mim_2f0fF A=400P P=80U
C$238 VOUTN|VOUTP VOUTN|VOUTP 2e-13 cap_mim_2f0fF A=100P P=40U
C$239 VOUTN|VOUTP VINN 8e-13 cap_mim_2f0fF A=400P P=80U
C$240 VOUTN|VOUTP VINP 8e-13 cap_mim_2f0fF A=400P P=80U
C$241 VOUTN|VOUTP VOUTN|VOUTP 2e-13 cap_mim_2f0fF A=100P P=40U
C$242 VOUTN|VOUTP VOUTN|VOUTP 2e-13 cap_mim_2f0fF A=100P P=40U
C$243 VOUTN|VOUTP VOUTN|VOUTP 2e-13 cap_mim_2f0fF A=100P P=40U
C$244 VOUTN|VOUTP VOUTN|VOUTP 2e-13 cap_mim_2f0fF A=100P P=40U
C$245 VOUTN|VOUTP VOUTN|VOUTP 2e-13 cap_mim_2f0fF A=100P P=40U
C$246 VOUTN|VOUTP VINN 8e-13 cap_mim_2f0fF A=400P P=80U
C$247 VOUTN|VOUTP VOUTN|VOUTP 2e-13 cap_mim_2f0fF A=100P P=40U
C$248 VOUTN|VOUTP VOUTN|VOUTP 2e-13 cap_mim_2f0fF A=100P P=40U
C$249 VOUTN|VOUTP VOUTN|VOUTP 2e-13 cap_mim_2f0fF A=100P P=40U
C$250 VOUTN|VOUTP VOUTN|VOUTP 2e-13 cap_mim_2f0fF A=100P P=40U
C$251 VOUTN|VOUTP VINP 8e-13 cap_mim_2f0fF A=400P P=80U
C$252 VOUTN|VOUTP VOUTN|VOUTP 2e-13 cap_mim_2f0fF A=100P P=40U
C$253 VOUTN|VOUTP VOUTN|VOUTP 2e-13 cap_mim_2f0fF A=100P P=40U
C$254 VOUTN|VOUTP VOUTN|VOUTP 2e-13 cap_mim_2f0fF A=100P P=40U
C$255 VOUTN|VOUTP VOUTN|VOUTP 2e-13 cap_mim_2f0fF A=100P P=40U
C$256 VOUTN|VOUTP VINP 8e-13 cap_mim_2f0fF A=400P P=80U
C$257 VOUTN|VOUTP VINP 8e-13 cap_mim_2f0fF A=400P P=80U
.ENDS ina
