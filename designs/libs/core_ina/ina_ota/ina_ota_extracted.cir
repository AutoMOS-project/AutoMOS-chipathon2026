* Extracted by KLayout with GF180MCU LVS runset on : 27/08/2026 22:09

.SUBCKT ina_ota VOUT1 VOUT2 VDD VIN2 VIN1 VTAIL VSS
M$1 VDD VDD VDD VDD pfet_03v3 L=6U W=2.6U AS=1.508P AD=1.508P PS=9.84U PD=9.84U
M$2 VOUT1 \$13 VDD VDD pfet_03v3 L=6U W=0.65U AS=0.39P AD=0.39P PS=2.5U PD=2.5U
M$3 \$10 VIN1 \$9 VDD pfet_03v3 L=0.28U W=150U AS=112.5P AD=112.5P PS=315U
+ PD=315U
M$4 VDD VDD VDD VDD pfet_03v3 L=0.28U W=30U AS=21.9P AD=21.9P PS=62.92U
+ PD=62.92U
M$5 \$2 VIN2 \$9 VDD pfet_03v3 L=0.28U W=150U AS=112.5P AD=112.5P PS=315U
+ PD=315U
M$7 VOUT2 \$12 VDD VDD pfet_03v3 L=6U W=0.65U AS=0.39P AD=0.39P PS=2.5U PD=2.5U
M$10 \$13 \$13 VDD VDD pfet_03v3 L=6U W=0.65U AS=0.39P AD=0.39P PS=2.5U PD=2.5U
M$12 VDD VDD VDD VDD pfet_03v3 L=2U W=16U AS=9.28P AD=9.28P PS=34.32U PD=34.32U
M$31 \$12 \$12 VDD VDD pfet_03v3 L=6U W=0.65U AS=0.39P AD=0.39P PS=2.5U PD=2.5U
M$33 \$9 VTAIL VDD VDD pfet_03v3 L=2U W=8U AS=4.8P AD=4.8P PS=17.2U PD=17.2U
M$34 VSS VSS VSS VSS nfet_03v3 L=6U W=7.2U AS=4.176P AD=4.176P PS=19.04U
+ PD=19.04U
M$35 \$13 \$10 VSS VSS nfet_03v3 L=6U W=1.8U AS=1.08P AD=1.08P PS=4.8U PD=4.8U
M$37 \$2 \$2 VSS VSS nfet_03v3 L=6U W=1.8U AS=1.08P AD=1.08P PS=4.8U PD=4.8U
M$38 \$12 \$2 VSS VSS nfet_03v3 L=6U W=1.8U AS=1.08P AD=1.08P PS=4.8U PD=4.8U
M$39 \$10 \$10 VSS VSS nfet_03v3 L=6U W=1.8U AS=1.08P AD=1.08P PS=4.8U PD=4.8U
M$40 VOUT1 \$2 VSS VSS nfet_03v3 L=6U W=1.8U AS=1.08P AD=1.08P PS=4.8U PD=4.8U
M$43 VOUT2 \$10 VSS VSS nfet_03v3 L=6U W=1.8U AS=1.08P AD=1.08P PS=4.8U PD=4.8U
.ENDS ina_ota
