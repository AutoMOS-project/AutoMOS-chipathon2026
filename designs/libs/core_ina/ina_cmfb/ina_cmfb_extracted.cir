* Extracted by KLayout with GF180MCU LVS runset on : 27/08/2026 22:54

.SUBCKT ina_cmfb VB VIN2 VCMFB VIN1 VCM VDD VSS
M$1 VDD VDD VDD VDD pfet_03v3 L=2U W=16U AS=9.28P AD=9.28P PS=34.32U PD=34.32U
M$2 \$11 \$11 VDD VDD pfet_03v3 L=2U W=8U AS=4.8P AD=4.8P PS=17.2U PD=17.2U
M$3 VCMFB VCMFB VDD VDD pfet_03v3 L=2U W=8U AS=4.8P AD=4.8P PS=17.2U PD=17.2U
M$5 VCMFB VIN1 \$3 VSS nfet_03v3 L=2U W=1.6U AS=0.96P AD=0.96P PS=4.4U PD=4.4U
M$6 VSS VSS VSS VSS nfet_03v3 L=2U W=12.8U AS=7.424P AD=7.424P PS=32.56U
+ PD=32.56U
M$9 \$11 VCM \$3 VSS nfet_03v3 L=2U W=1.6U AS=0.96P AD=0.96P PS=4.4U PD=4.4U
M$10 \$11 VCM \$6 VSS nfet_03v3 L=2U W=1.6U AS=0.96P AD=0.96P PS=4.4U PD=4.4U
M$13 VCMFB VIN2 \$6 VSS nfet_03v3 L=2U W=1.6U AS=0.96P AD=0.96P PS=4.4U PD=4.4U
M$14 \$3 VB VSS VSS nfet_03v3 L=2U W=3.2U AS=1.92P AD=1.92P PS=7.6U PD=7.6U
M$15 \$6 VB VSS VSS nfet_03v3 L=2U W=3.2U AS=1.92P AD=1.92P PS=7.6U PD=7.6U
.ENDS ina_cmfb
