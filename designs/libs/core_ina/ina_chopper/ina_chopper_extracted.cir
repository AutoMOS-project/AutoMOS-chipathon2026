* Extracted by KLayout with GF180MCU LVS runset on : 28/08/2026 06:30

.SUBCKT ina_chopper CLKB CLKA VOUT1 VOUT2 VDD VIN1 VIN2 VSS
M$1 VOUT1 CLKA VIN2 VDD pfet_03v3 L=0.28U W=4U AS=3P AD=3P PS=9.5U PD=9.5U
M$2 VOUT1 CLKA VOUT1 VDD pfet_03v3 L=0.28U W=2U AS=1.5P AD=1.5P PS=5.5U PD=5.5U
M$3 VOUT2 CLKA VIN1 VDD pfet_03v3 L=0.28U W=4U AS=3P AD=3P PS=9.5U PD=9.5U
M$4 VOUT2 CLKB VOUT2 VDD pfet_03v3 L=0.28U W=2U AS=1.5P AD=1.5P PS=5.5U PD=5.5U
M$5 VOUT1 CLKB VOUT1 VDD pfet_03v3 L=0.28U W=2U AS=1.5P AD=1.5P PS=5.5U PD=5.5U
M$6 VOUT2 CLKA VOUT2 VDD pfet_03v3 L=0.28U W=2U AS=1.5P AD=1.5P PS=5.5U PD=5.5U
M$7 VOUT2 CLKB VIN2 VDD pfet_03v3 L=0.28U W=4U AS=3P AD=3P PS=9.5U PD=9.5U
M$8 VOUT1 CLKB VIN1 VDD pfet_03v3 L=0.28U W=4U AS=3P AD=3P PS=9.5U PD=9.5U
M$9 VOUT2 CLKA VIN2 VSS nfet_03v3 L=0.28U W=2U AS=1.5P AD=1.5P PS=5.5U PD=5.5U
M$10 VOUT1 CLKB VOUT1 VSS nfet_03v3 L=0.28U W=1U AS=0.75P AD=0.75P PS=3.5U
+ PD=3.5U
M$11 VOUT1 CLKA VIN1 VSS nfet_03v3 L=0.28U W=2U AS=1.5P AD=1.5P PS=5.5U PD=5.5U
M$12 VOUT1 CLKB VIN2 VSS nfet_03v3 L=0.28U W=2U AS=1.5P AD=1.5P PS=5.5U PD=5.5U
M$13 VOUT2 CLKB VIN1 VSS nfet_03v3 L=0.28U W=2U AS=1.5P AD=1.5P PS=5.5U PD=5.5U
M$14 VOUT2 CLKA VOUT2 VSS nfet_03v3 L=0.28U W=1U AS=0.75P AD=0.75P PS=3.5U
+ PD=3.5U
M$15 VOUT1 CLKA VOUT1 VSS nfet_03v3 L=0.28U W=1U AS=0.75P AD=0.75P PS=3.5U
+ PD=3.5U
M$16 VOUT2 CLKB VOUT2 VSS nfet_03v3 L=0.28U W=1U AS=0.75P AD=0.75P PS=3.5U
+ PD=3.5U
.ENDS ina_chopper
