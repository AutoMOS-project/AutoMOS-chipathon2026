* Extracted by KLayout with GF180MCU LVS runset on : 28/08/2026 16:27

.SUBCKT ina_ccia1
M$1 VDD VDD VDD VDD pfet_03v3 L=0.28U W=15U AS=10.95P AD=10.95P PS=31.46U
+ PD=31.46U
M$2 \$66 \$1063 \$751 VDD pfet_03v3 L=0.28U W=15U AS=11.25P AD=11.25P PS=31.5U
+ PD=31.5U
M$3 \$66 \$1063 \$751 VDD pfet_03v3 L=0.28U W=15U AS=11.25P AD=11.25P PS=31.5U
+ PD=31.5U
M$4 \$66 \$1063 \$751 VDD pfet_03v3 L=0.28U W=15U AS=11.25P AD=11.25P PS=31.5U
+ PD=31.5U
M$5 \$66 \$1063 \$751 VDD pfet_03v3 L=0.28U W=15U AS=11.25P AD=11.25P PS=31.5U
+ PD=31.5U
M$6 \$66 \$1063 \$751 VDD pfet_03v3 L=0.28U W=15U AS=11.25P AD=11.25P PS=31.5U
+ PD=31.5U
M$7 \$66 \$1063 \$751 VDD pfet_03v3 L=0.28U W=15U AS=11.25P AD=11.25P PS=31.5U
+ PD=31.5U
M$8 \$66 \$1063 \$751 VDD pfet_03v3 L=0.28U W=15U AS=11.25P AD=11.25P PS=31.5U
+ PD=31.5U
M$9 \$66 \$1063 \$751 VDD pfet_03v3 L=0.28U W=15U AS=11.25P AD=11.25P PS=31.5U
+ PD=31.5U
M$10 \$66 \$1063 \$751 VDD pfet_03v3 L=0.28U W=15U AS=11.25P AD=11.25P PS=31.5U
+ PD=31.5U
M$11 \$66 \$1063 \$751 VDD pfet_03v3 L=0.28U W=15U AS=11.25P AD=11.25P PS=31.5U
+ PD=31.5U
M$12 \$752 \$1062 \$751 VDD pfet_03v3 L=0.28U W=15U AS=11.25P AD=11.25P
+ PS=31.5U PD=31.5U
M$13 \$752 \$1062 \$751 VDD pfet_03v3 L=0.28U W=15U AS=11.25P AD=11.25P
+ PS=31.5U PD=31.5U
M$14 \$752 \$1062 \$751 VDD pfet_03v3 L=0.28U W=15U AS=11.25P AD=11.25P
+ PS=31.5U PD=31.5U
M$15 \$752 \$1062 \$751 VDD pfet_03v3 L=0.28U W=15U AS=11.25P AD=11.25P
+ PS=31.5U PD=31.5U
M$16 \$752 \$1062 \$751 VDD pfet_03v3 L=0.28U W=15U AS=11.25P AD=11.25P
+ PS=31.5U PD=31.5U
M$17 \$752 \$1062 \$751 VDD pfet_03v3 L=0.28U W=15U AS=11.25P AD=11.25P
+ PS=31.5U PD=31.5U
M$18 \$752 \$1062 \$751 VDD pfet_03v3 L=0.28U W=15U AS=11.25P AD=11.25P
+ PS=31.5U PD=31.5U
M$19 \$752 \$1062 \$751 VDD pfet_03v3 L=0.28U W=15U AS=11.25P AD=11.25P
+ PS=31.5U PD=31.5U
M$20 \$752 \$1062 \$751 VDD pfet_03v3 L=0.28U W=15U AS=11.25P AD=11.25P
+ PS=31.5U PD=31.5U
M$21 \$752 \$1062 \$751 VDD pfet_03v3 L=0.28U W=15U AS=11.25P AD=11.25P
+ PS=31.5U PD=31.5U
M$22 VDD VDD VDD VDD pfet_03v3 L=0.28U W=15U AS=10.95P AD=10.95P PS=31.46U
+ PD=31.46U
M$23 VDD VDD VDD VDD pfet_03v3 L=6U W=0.65U AS=0.377P AD=0.377P PS=2.46U
+ PD=2.46U
M$24 \$765 \$1068 VDD VDD pfet_03v3 L=6U W=0.65U AS=0.39P AD=0.39P PS=2.5U
+ PD=2.5U
M$25 VDD VDD VDD VDD pfet_03v3 L=2U W=8U AS=4.64P AD=4.64P PS=17.16U PD=17.16U
M$26 \$751 \$1059 VDD VDD pfet_03v3 L=2U W=8U AS=4.8P AD=4.8P PS=17.2U PD=17.2U
M$27 \$1068 \$1068 VDD VDD pfet_03v3 L=6U W=0.65U AS=0.39P AD=0.39P PS=2.5U
+ PD=2.5U
M$28 VDD VDD VDD VDD pfet_03v3 L=2U W=8U AS=4.64P AD=4.64P PS=17.16U PD=17.16U
M$29 VDD VDD VDD VDD pfet_03v3 L=6U W=0.65U AS=0.377P AD=0.377P PS=2.46U
+ PD=2.46U
M$30 \$1062 CLKB \$760 VDD pfet_03v3 L=0.28U W=4U AS=3P AD=3P PS=9.5U PD=9.5U
M$31 VOUTP CLKB \$761 VDD pfet_03v3 L=0.28U W=4U AS=3P AD=3P PS=9.5U PD=9.5U
M$32 VOUTP CLKA VOUTP VDD pfet_03v3 L=0.28U W=2U AS=1.5P AD=1.5P PS=5.5U PD=5.5U
M$33 VOUTN CLKA \$761 VDD pfet_03v3 L=0.28U W=4U AS=3P AD=3P PS=9.5U PD=9.5U
M$34 \$1063 CLKA \$760 VDD pfet_03v3 L=0.28U W=4U AS=3P AD=3P PS=9.5U PD=9.5U
M$35 VOUTN CLKB VOUTN VDD pfet_03v3 L=0.28U W=2U AS=1.5P AD=1.5P PS=5.5U PD=5.5U
M$36 \$1063 CLKB \$759 VDD pfet_03v3 L=0.28U W=4U AS=3P AD=3P PS=9.5U PD=9.5U
M$37 VOUTN CLKB \$765 VDD pfet_03v3 L=0.28U W=4U AS=3P AD=3P PS=9.5U PD=9.5U
M$38 VOUTN CLKA VOUTN VDD pfet_03v3 L=0.28U W=2U AS=1.5P AD=1.5P PS=5.5U PD=5.5U
M$39 VOUTP CLKA \$765 VDD pfet_03v3 L=0.28U W=4U AS=3P AD=3P PS=9.5U PD=9.5U
M$40 \$1062 CLKA \$759 VDD pfet_03v3 L=0.28U W=4U AS=3P AD=3P PS=9.5U PD=9.5U
M$41 VOUTP CLKB VOUTP VDD pfet_03v3 L=0.28U W=2U AS=1.5P AD=1.5P PS=5.5U PD=5.5U
M$42 VDD VDD VDD VDD pfet_03v3 L=2U W=8U AS=4.64P AD=4.64P PS=17.16U PD=17.16U
M$43 \$1059 \$1059 VDD VDD pfet_03v3 L=2U W=8U AS=4.8P AD=4.8P PS=17.2U PD=17.2U
M$44 \$1073 \$1073 VDD VDD pfet_03v3 L=2U W=8U AS=4.8P AD=4.8P PS=17.2U PD=17.2U
M$45 VDD VDD VDD VDD pfet_03v3 L=2U W=8U AS=4.64P AD=4.64P PS=17.16U PD=17.16U
M$46 VDD VDD VDD VDD pfet_03v3 L=6U W=0.65U AS=0.377P AD=0.377P PS=2.46U
+ PD=2.46U
M$47 \$1076 \$1076 VDD VDD pfet_03v3 L=6U W=0.65U AS=0.39P AD=0.39P PS=2.5U
+ PD=2.5U
M$48 \$761 \$1076 VDD VDD pfet_03v3 L=6U W=0.65U AS=0.39P AD=0.39P PS=2.5U
+ PD=2.5U
M$49 VDD VDD VDD VDD pfet_03v3 L=6U W=0.65U AS=0.377P AD=0.377P PS=2.46U
+ PD=2.46U
M$50 \$1062 CLKA \$1062 VDD pfet_03v3 L=0.28U W=2U AS=1.5P AD=1.5P PS=5.5U
+ PD=5.5U
M$51 \$1063 CLKB \$1063 VDD pfet_03v3 L=0.28U W=2U AS=1.5P AD=1.5P PS=5.5U
+ PD=5.5U
M$52 \$1063 CLKA \$1063 VDD pfet_03v3 L=0.28U W=2U AS=1.5P AD=1.5P PS=5.5U
+ PD=5.5U
M$53 \$1062 CLKB \$1062 VDD pfet_03v3 L=0.28U W=2U AS=1.5P AD=1.5P PS=5.5U
+ PD=5.5U
M$54 VSS VSS VSS VSS nfet_03v3 L=6U W=1.8U AS=1.044P AD=1.044P PS=4.76U PD=4.76U
M$55 \$66 \$66 VSS VSS nfet_03v3 L=6U W=1.8U AS=1.08P AD=1.08P PS=4.8U PD=4.8U
M$56 \$1068 \$66 VSS VSS nfet_03v3 L=6U W=1.8U AS=1.08P AD=1.08P PS=4.8U PD=4.8U
M$57 \$761 \$66 VSS VSS nfet_03v3 L=6U W=1.8U AS=1.08P AD=1.08P PS=4.8U PD=4.8U
M$58 VSS VSS VSS VSS nfet_03v3 L=6U W=1.8U AS=1.044P AD=1.044P PS=4.76U PD=4.76U
M$59 VSS VSS VSS VSS nfet_03v3 L=6U W=1.8U AS=1.044P AD=1.044P PS=4.76U PD=4.76U
M$60 \$765 \$752 VSS VSS nfet_03v3 L=6U W=1.8U AS=1.08P AD=1.08P PS=4.8U PD=4.8U
M$61 \$1076 \$752 VSS VSS nfet_03v3 L=6U W=1.8U AS=1.08P AD=1.08P PS=4.8U
+ PD=4.8U
M$62 \$752 \$752 VSS VSS nfet_03v3 L=6U W=1.8U AS=1.08P AD=1.08P PS=4.8U PD=4.8U
M$63 VSS VSS VSS VSS nfet_03v3 L=6U W=1.8U AS=1.044P AD=1.044P PS=4.76U PD=4.76U
M$64 VOUTP CLKA \$761 VSS nfet_03v3 L=0.28U W=2U AS=1.5P AD=1.5P PS=5.5U PD=5.5U
M$65 VOUTP CLKB VOUTP VSS nfet_03v3 L=0.28U W=1U AS=0.75P AD=0.75P PS=3.5U
+ PD=3.5U
M$66 VOUTN CLKB \$761 VSS nfet_03v3 L=0.28U W=2U AS=1.5P AD=1.5P PS=5.5U PD=5.5U
M$67 VOUTN CLKA VOUTN VSS nfet_03v3 L=0.28U W=1U AS=0.75P AD=0.75P PS=3.5U
+ PD=3.5U
M$68 VOUTN CLKA \$765 VSS nfet_03v3 L=0.28U W=2U AS=1.5P AD=1.5P PS=5.5U PD=5.5U
M$69 VOUTN CLKB VOUTN VSS nfet_03v3 L=0.28U W=1U AS=0.75P AD=0.75P PS=3.5U
+ PD=3.5U
M$70 VOUTP CLKB \$765 VSS nfet_03v3 L=0.28U W=2U AS=1.5P AD=1.5P PS=5.5U PD=5.5U
M$71 VOUTP CLKA VOUTP VSS nfet_03v3 L=0.28U W=1U AS=0.75P AD=0.75P PS=3.5U
+ PD=3.5U
M$72 VSS VSS VSS VSS nfet_03v3 L=2U W=1.6U AS=0.928P AD=0.928P PS=4.36U PD=4.36U
M$73 VSS VSS VSS VSS nfet_03v3 L=2U W=3.2U AS=1.856P AD=1.856P PS=7.56U PD=7.56U
M$74 \$1059 \$765 \$1058 VSS nfet_03v3 L=2U W=1.6U AS=0.96P AD=0.96P PS=4.4U
+ PD=4.4U
M$75 \$766 VB VSS VSS nfet_03v3 L=2U W=3.2U AS=1.92P AD=1.92P PS=7.6U PD=7.6U
M$76 \$1073 VCM \$1058 VSS nfet_03v3 L=2U W=1.6U AS=0.96P AD=0.96P PS=4.4U
+ PD=4.4U
M$77 \$1058 VB VSS VSS nfet_03v3 L=2U W=3.2U AS=1.92P AD=1.92P PS=7.6U PD=7.6U
M$78 VSS VSS VSS VSS nfet_03v3 L=2U W=1.6U AS=0.928P AD=0.928P PS=4.36U PD=4.36U
M$79 VSS VSS VSS VSS nfet_03v3 L=2U W=3.2U AS=1.856P AD=1.856P PS=7.56U PD=7.56U
M$80 VSS VSS VSS VSS nfet_03v3 L=2U W=1.6U AS=0.928P AD=0.928P PS=4.36U PD=4.36U
M$81 \$1059 \$761 \$766 VSS nfet_03v3 L=2U W=1.6U AS=0.96P AD=0.96P PS=4.4U
+ PD=4.4U
M$82 \$1073 VCM \$766 VSS nfet_03v3 L=2U W=1.6U AS=0.96P AD=0.96P PS=4.4U
+ PD=4.4U
M$83 VSS VSS VSS VSS nfet_03v3 L=2U W=1.6U AS=0.928P AD=0.928P PS=4.36U PD=4.36U
M$84 \$1062 CLKA \$760 VSS nfet_03v3 L=0.28U W=2U AS=1.5P AD=1.5P PS=5.5U
+ PD=5.5U
M$85 \$1062 CLKB \$1062 VSS nfet_03v3 L=0.28U W=1U AS=0.75P AD=0.75P PS=3.5U
+ PD=3.5U
M$86 \$1063 CLKB \$760 VSS nfet_03v3 L=0.28U W=2U AS=1.5P AD=1.5P PS=5.5U
+ PD=5.5U
M$87 \$1063 CLKA \$1063 VSS nfet_03v3 L=0.28U W=1U AS=0.75P AD=0.75P PS=3.5U
+ PD=3.5U
M$88 \$1063 CLKA \$759 VSS nfet_03v3 L=0.28U W=2U AS=1.5P AD=1.5P PS=5.5U
+ PD=5.5U
M$89 \$1063 CLKB \$1063 VSS nfet_03v3 L=0.28U W=1U AS=0.75P AD=0.75P PS=3.5U
+ PD=3.5U
M$90 \$1062 CLKB \$759 VSS nfet_03v3 L=0.28U W=2U AS=1.5P AD=1.5P PS=5.5U
+ PD=5.5U
M$91 \$1062 CLKA \$1062 VSS nfet_03v3 L=0.28U W=1U AS=0.75P AD=0.75P PS=3.5U
+ PD=3.5U
M$92 \$1061 \$1060 \$1060 \$1060 nfet_03v3 L=12U W=0.5U AS=0.3P AD=0.3P PS=2.2U
+ PD=2.2U
M$93 \$760 VG VG VG nfet_03v3 L=5U W=0.5U AS=0.3P AD=0.3P PS=2.2U PD=2.2U
M$94 VOUTP \$1060 \$1060 \$1060 nfet_03v3 L=12U W=0.5U AS=0.3P AD=0.3P PS=2.2U
+ PD=2.2U
M$95 \$1061 VG VG VG nfet_03v3 L=5U W=0.5U AS=0.3P AD=0.3P PS=2.2U PD=2.2U
M$96 \$430 VG VG VG nfet_03v3 L=5U W=0.5U AS=0.3P AD=0.3P PS=2.2U PD=2.2U
M$97 VOUTN \$248 \$248 \$248 nfet_03v3 L=12U W=0.5U AS=0.3P AD=0.3P PS=2.2U
+ PD=2.2U
M$98 \$430 \$248 \$248 \$248 nfet_03v3 L=12U W=0.5U AS=0.3P AD=0.3P PS=2.2U
+ PD=2.2U
M$99 \$759 VG VG VG nfet_03v3 L=5U W=0.5U AS=0.3P AD=0.3P PS=2.2U PD=2.2U
C$100 \$759 VINN 8e-13 cap_mim_2f0fF A=400P P=80U
C$101 \$759 VINN 8e-13 cap_mim_2f0fF A=400P P=80U
C$102 VOUTN VOUTP 2e-13 cap_mim_2f0fF A=100P P=40U
C$103 VOUTN VOUTP 2e-13 cap_mim_2f0fF A=100P P=40U
C$104 VOUTN VOUTP 2e-13 cap_mim_2f0fF A=100P P=40U
C$105 VOUTN VOUTP 2e-13 cap_mim_2f0fF A=100P P=40U
C$106 \$759 VINN 8e-13 cap_mim_2f0fF A=400P P=80U
C$107 \$760 VINP 8e-13 cap_mim_2f0fF A=400P P=80U
C$108 VOUTN VOUTP 2e-13 cap_mim_2f0fF A=100P P=40U
C$109 VOUTN \$759 2e-13 cap_mim_2f0fF A=100P P=40U
C$110 \$759 VINN 8e-13 cap_mim_2f0fF A=400P P=80U
C$111 VOUTP \$760 2e-13 cap_mim_2f0fF A=100P P=40U
C$112 \$760 VINP 8e-13 cap_mim_2f0fF A=400P P=80U
C$113 \$760 VINP 8e-13 cap_mim_2f0fF A=400P P=80U
C$114 \$759 VINN 8e-13 cap_mim_2f0fF A=400P P=80U
C$115 \$760 VINP 8e-13 cap_mim_2f0fF A=400P P=80U
C$116 \$760 VINP 8e-13 cap_mim_2f0fF A=400P P=80U
.ENDS ina_ccia1
