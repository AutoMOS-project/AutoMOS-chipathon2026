* Extracted by KLayout with GF180MCU LVS runset on : 28/08/2026 16:39

.SUBCKT ina_ccia2 VOUTP VG CLKA CLKB VDD VOUTN VB VCM VINP VINN VSS
M$1 VDD VDD VDD VDD pfet_03v3 L=0.28U W=30U AS=21.9P AD=21.9P PS=62.92U
+ PD=62.92U
M$2 \$66 \$1063 \$751 VDD pfet_03v3 L=0.28U W=150U AS=112.5P AD=112.5P PS=315U
+ PD=315U
M$12 \$752 \$1062 \$751 VDD pfet_03v3 L=0.28U W=150U AS=112.5P AD=112.5P
+ PS=315U PD=315U
M$23 VDD VDD VDD VDD pfet_03v3 L=6U W=2.6U AS=1.508P AD=1.508P PS=9.84U PD=9.84U
M$24 \$762 \$1068 VDD VDD pfet_03v3 L=6U W=0.65U AS=0.39P AD=0.39P PS=2.5U
+ PD=2.5U
M$25 VDD VDD VDD VDD pfet_03v3 L=2U W=32U AS=18.56P AD=18.56P PS=68.64U
+ PD=68.64U
M$26 \$751 \$1059 VDD VDD pfet_03v3 L=2U W=8U AS=4.8P AD=4.8P PS=17.2U PD=17.2U
M$27 \$1068 \$1068 VDD VDD pfet_03v3 L=6U W=0.65U AS=0.39P AD=0.39P PS=2.5U
+ PD=2.5U
M$30 VOUTP CLKB \$761 VDD pfet_03v3 L=0.28U W=4U AS=3P AD=3P PS=9.5U PD=9.5U
M$31 \$1062 CLKB \$760 VDD pfet_03v3 L=0.28U W=4U AS=3P AD=3P PS=9.5U PD=9.5U
M$32 VOUTP CLKA VOUTP VDD pfet_03v3 L=0.28U W=2U AS=1.5P AD=1.5P PS=5.5U PD=5.5U
M$33 \$1063 CLKA \$760 VDD pfet_03v3 L=0.28U W=4U AS=3P AD=3P PS=9.5U PD=9.5U
M$34 VOUTN CLKA \$761 VDD pfet_03v3 L=0.28U W=4U AS=3P AD=3P PS=9.5U PD=9.5U
M$35 VOUTN CLKB VOUTN VDD pfet_03v3 L=0.28U W=2U AS=1.5P AD=1.5P PS=5.5U PD=5.5U
M$36 VOUTN CLKB \$762 VDD pfet_03v3 L=0.28U W=4U AS=3P AD=3P PS=9.5U PD=9.5U
M$37 \$1063 CLKB \$759 VDD pfet_03v3 L=0.28U W=4U AS=3P AD=3P PS=9.5U PD=9.5U
M$38 VOUTN CLKA VOUTN VDD pfet_03v3 L=0.28U W=2U AS=1.5P AD=1.5P PS=5.5U PD=5.5U
M$39 \$1062 CLKA \$759 VDD pfet_03v3 L=0.28U W=4U AS=3P AD=3P PS=9.5U PD=9.5U
M$40 VOUTP CLKA \$762 VDD pfet_03v3 L=0.28U W=4U AS=3P AD=3P PS=9.5U PD=9.5U
M$41 VOUTP CLKB VOUTP VDD pfet_03v3 L=0.28U W=2U AS=1.5P AD=1.5P PS=5.5U PD=5.5U
M$43 \$1059 \$1059 VDD VDD pfet_03v3 L=2U W=8U AS=4.8P AD=4.8P PS=17.2U PD=17.2U
M$44 \$1073 \$1073 VDD VDD pfet_03v3 L=2U W=8U AS=4.8P AD=4.8P PS=17.2U PD=17.2U
M$47 \$1076 \$1076 VDD VDD pfet_03v3 L=6U W=0.65U AS=0.39P AD=0.39P PS=2.5U
+ PD=2.5U
M$48 \$761 \$1076 VDD VDD pfet_03v3 L=6U W=0.65U AS=0.39P AD=0.39P PS=2.5U
+ PD=2.5U
M$50 \$1062 CLKA \$1062 VDD pfet_03v3 L=0.28U W=2U AS=1.5P AD=1.5P PS=5.5U
+ PD=5.5U
M$51 \$1063 CLKB \$1063 VDD pfet_03v3 L=0.28U W=2U AS=1.5P AD=1.5P PS=5.5U
+ PD=5.5U
M$52 \$1063 CLKA \$1063 VDD pfet_03v3 L=0.28U W=2U AS=1.5P AD=1.5P PS=5.5U
+ PD=5.5U
M$53 \$1062 CLKB \$1062 VDD pfet_03v3 L=0.28U W=2U AS=1.5P AD=1.5P PS=5.5U
+ PD=5.5U
M$54 VSS VSS VSS VSS nfet_03v3 L=6U W=7.2U AS=4.176P AD=4.176P PS=19.04U
+ PD=19.04U
M$55 \$66 \$66 VSS VSS nfet_03v3 L=6U W=1.8U AS=1.08P AD=1.08P PS=4.8U PD=4.8U
M$56 \$1068 \$66 VSS VSS nfet_03v3 L=6U W=1.8U AS=1.08P AD=1.08P PS=4.8U PD=4.8U
M$57 \$761 \$66 VSS VSS nfet_03v3 L=6U W=1.8U AS=1.08P AD=1.08P PS=4.8U PD=4.8U
M$60 \$762 \$752 VSS VSS nfet_03v3 L=6U W=1.8U AS=1.08P AD=1.08P PS=4.8U PD=4.8U
M$61 \$1076 \$752 VSS VSS nfet_03v3 L=6U W=1.8U AS=1.08P AD=1.08P PS=4.8U
+ PD=4.8U
M$62 \$752 \$752 VSS VSS nfet_03v3 L=6U W=1.8U AS=1.08P AD=1.08P PS=4.8U PD=4.8U
M$64 VOUTP CLKA \$761 VSS nfet_03v3 L=0.28U W=2U AS=1.5P AD=1.5P PS=5.5U PD=5.5U
M$65 VOUTP CLKB VOUTP VSS nfet_03v3 L=0.28U W=1U AS=0.75P AD=0.75P PS=3.5U
+ PD=3.5U
M$66 VOUTN CLKB \$761 VSS nfet_03v3 L=0.28U W=2U AS=1.5P AD=1.5P PS=5.5U PD=5.5U
M$67 VOUTN CLKA VOUTN VSS nfet_03v3 L=0.28U W=1U AS=0.75P AD=0.75P PS=3.5U
+ PD=3.5U
M$68 VOUTN CLKA \$762 VSS nfet_03v3 L=0.28U W=2U AS=1.5P AD=1.5P PS=5.5U PD=5.5U
M$69 VOUTN CLKB VOUTN VSS nfet_03v3 L=0.28U W=1U AS=0.75P AD=0.75P PS=3.5U
+ PD=3.5U
M$70 VOUTP CLKB \$762 VSS nfet_03v3 L=0.28U W=2U AS=1.5P AD=1.5P PS=5.5U PD=5.5U
M$71 VOUTP CLKA VOUTP VSS nfet_03v3 L=0.28U W=1U AS=0.75P AD=0.75P PS=3.5U
+ PD=3.5U
M$72 VSS VSS VSS VSS nfet_03v3 L=2U W=12.8U AS=7.424P AD=7.424P PS=32.56U
+ PD=32.56U
M$74 \$1059 \$762 \$1058 VSS nfet_03v3 L=2U W=1.6U AS=0.96P AD=0.96P PS=4.4U
+ PD=4.4U
M$75 \$766 VB VSS VSS nfet_03v3 L=2U W=3.2U AS=1.92P AD=1.92P PS=7.6U PD=7.6U
M$76 \$1073 VCM \$1058 VSS nfet_03v3 L=2U W=1.6U AS=0.96P AD=0.96P PS=4.4U
+ PD=4.4U
M$77 \$1058 VB VSS VSS nfet_03v3 L=2U W=3.2U AS=1.92P AD=1.92P PS=7.6U PD=7.6U
M$81 \$1059 \$761 \$766 VSS nfet_03v3 L=2U W=1.6U AS=0.96P AD=0.96P PS=4.4U
+ PD=4.4U
M$82 \$1073 VCM \$766 VSS nfet_03v3 L=2U W=1.6U AS=0.96P AD=0.96P PS=4.4U
+ PD=4.4U
M$84 \$1062 CLKA \$760 VSS nfet_03v3 L=0.28U W=2U AS=1.5P AD=1.5P PS=5.5U
+ PD=5.5U
M$85 \$1062 CLKB \$1062 VSS nfet_03v3 L=0.28U W=1U AS=0.75P AD=0.75P PS=3.5U
+ PD=3.5U
M$86 \$1063 CLKB \$760 VSS nfet_03v3 L=0.28U W=2U AS=1.5P AD=1.5P PS=5.5U
+ PD=5.5U
M$87 \$1063 CLKA \$1063 VSS nfet_03v3 L=0.28U W=1U AS=0.75P AD=0.75P PS=3.5U
+ PD=3.5U
M$88 \$1063 CLKA \$759 VSS nfet_03v3 L=0.28U W=2U AS=1.5P AD=1.5P PS=5.5U
+ PD=5.5U
M$89 \$1063 CLKB \$1063 VSS nfet_03v3 L=0.28U W=1U AS=0.75P AD=0.75P PS=3.5U
+ PD=3.5U
M$90 \$1062 CLKB \$759 VSS nfet_03v3 L=0.28U W=2U AS=1.5P AD=1.5P PS=5.5U
+ PD=5.5U
M$91 \$1062 CLKA \$1062 VSS nfet_03v3 L=0.28U W=1U AS=0.75P AD=0.75P PS=3.5U
+ PD=3.5U
M$92 \$1061 \$1060 \$1060 \$1060 nfet_03v3 L=12U W=0.5U AS=0.3P AD=0.3P PS=2.2U
+ PD=2.2U
M$93 \$760 VG VG VG nfet_03v3 L=5U W=0.5U AS=0.3P AD=0.3P PS=2.2U PD=2.2U
M$94 VOUTP \$1060 \$1060 \$1060 nfet_03v3 L=12U W=0.5U AS=0.3P AD=0.3P PS=2.2U
+ PD=2.2U
M$95 \$1061 VG VG VG nfet_03v3 L=5U W=0.5U AS=0.3P AD=0.3P PS=2.2U PD=2.2U
M$96 \$430 VG VG VG nfet_03v3 L=5U W=0.5U AS=0.3P AD=0.3P PS=2.2U PD=2.2U
M$97 VOUTN \$248 \$248 \$248 nfet_03v3 L=12U W=0.5U AS=0.3P AD=0.3P PS=2.2U
+ PD=2.2U
M$98 \$430 \$248 \$248 \$248 nfet_03v3 L=12U W=0.5U AS=0.3P AD=0.3P PS=2.2U
+ PD=2.2U
M$99 \$759 VG VG VG nfet_03v3 L=5U W=0.5U AS=0.3P AD=0.3P PS=2.2U PD=2.2U
C$100 \$759 VINN 1e-12 cap_mim_2f0fF A=500P P=200U
C$104 VOUTN VOUTP 1e-12 cap_mim_2f0fF A=500P P=200U
C$109 VOUTP \$760 2e-13 cap_mim_2f0fF A=100P P=40U
C$110 VOUTN \$759 2e-13 cap_mim_2f0fF A=100P P=40U
C$111 \$760 VINP 1e-12 cap_mim_2f0fF A=500P P=200U
.ENDS ina_ccia2
