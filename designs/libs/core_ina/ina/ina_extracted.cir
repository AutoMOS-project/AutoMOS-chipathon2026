* Extracted by KLayout with GF180MCU LVS runset on : 28/08/2026 17:39

.SUBCKT ina VOUTP VG VDD VOUTN VCM CLK IB VINP VINN VSS
M$1 VDD VDD VDD VDD pfet_03v3 L=0.28U W=60U AS=43.8P AD=43.8P PS=125.84U
+ PD=125.84U
M$2 \$66 \$1062 \$751 VDD pfet_03v3 L=0.28U W=150U AS=112.5P AD=112.5P PS=315U
+ PD=315U
M$12 \$752 \$1061 \$751 VDD pfet_03v3 L=0.28U W=150U AS=112.5P AD=112.5P
+ PS=315U PD=315U
M$23 VDD VDD VDD VDD pfet_03v3 L=6U W=5.2U AS=3.016P AD=3.016P PS=19.68U
+ PD=19.68U
M$24 \$762 \$1067 VDD VDD pfet_03v3 L=6U W=0.65U AS=0.39P AD=0.39P PS=2.5U
+ PD=2.5U
M$25 VDD VDD VDD VDD pfet_03v3 L=2U W=64U AS=37.12P AD=37.12P PS=137.28U
+ PD=137.28U
M$26 \$751 \$1058 VDD VDD pfet_03v3 L=2U W=8U AS=4.8P AD=4.8P PS=17.2U PD=17.2U
M$27 \$1067 \$1067 VDD VDD pfet_03v3 L=6U W=0.65U AS=0.39P AD=0.39P PS=2.5U
+ PD=2.5U
M$30 VOUTP \$742 \$761 VDD pfet_03v3 L=0.28U W=4U AS=3P AD=3P PS=9.5U PD=9.5U
M$31 \$1061 \$742 \$760 VDD pfet_03v3 L=0.28U W=4U AS=3P AD=3P PS=9.5U PD=9.5U
M$32 VOUTP \$741 VOUTP VDD pfet_03v3 L=0.28U W=2U AS=1.5P AD=1.5P PS=5.5U
+ PD=5.5U
M$33 \$1062 \$741 \$760 VDD pfet_03v3 L=0.28U W=4U AS=3P AD=3P PS=9.5U PD=9.5U
M$34 VOUTN \$741 \$761 VDD pfet_03v3 L=0.28U W=4U AS=3P AD=3P PS=9.5U PD=9.5U
M$35 VOUTN \$742 VOUTN VDD pfet_03v3 L=0.28U W=2U AS=1.5P AD=1.5P PS=5.5U
+ PD=5.5U
M$36 VOUTN \$742 \$762 VDD pfet_03v3 L=0.28U W=4U AS=3P AD=3P PS=9.5U PD=9.5U
M$37 \$1062 \$742 \$759 VDD pfet_03v3 L=0.28U W=4U AS=3P AD=3P PS=9.5U PD=9.5U
M$38 VOUTN \$741 VOUTN VDD pfet_03v3 L=0.28U W=2U AS=1.5P AD=1.5P PS=5.5U
+ PD=5.5U
M$39 VOUTP \$741 \$762 VDD pfet_03v3 L=0.28U W=4U AS=3P AD=3P PS=9.5U PD=9.5U
M$40 \$1061 \$741 \$759 VDD pfet_03v3 L=0.28U W=4U AS=3P AD=3P PS=9.5U PD=9.5U
M$41 VOUTP \$742 VOUTP VDD pfet_03v3 L=0.28U W=2U AS=1.5P AD=1.5P PS=5.5U
+ PD=5.5U
M$43 \$1058 \$1058 VDD VDD pfet_03v3 L=2U W=8U AS=4.8P AD=4.8P PS=17.2U PD=17.2U
M$44 \$1072 \$1072 VDD VDD pfet_03v3 L=2U W=8U AS=4.8P AD=4.8P PS=17.2U PD=17.2U
M$47 \$1075 \$1075 VDD VDD pfet_03v3 L=6U W=0.65U AS=0.39P AD=0.39P PS=2.5U
+ PD=2.5U
M$48 \$761 \$1075 VDD VDD pfet_03v3 L=6U W=0.65U AS=0.39P AD=0.39P PS=2.5U
+ PD=2.5U
M$50 \$1061 \$741 \$1061 VDD pfet_03v3 L=0.28U W=2U AS=1.5P AD=1.5P PS=5.5U
+ PD=5.5U
M$51 \$1062 \$742 \$1062 VDD pfet_03v3 L=0.28U W=2U AS=1.5P AD=1.5P PS=5.5U
+ PD=5.5U
M$52 \$1062 \$741 \$1062 VDD pfet_03v3 L=0.28U W=2U AS=1.5P AD=1.5P PS=5.5U
+ PD=5.5U
M$53 \$1061 \$742 \$1061 VDD pfet_03v3 L=0.28U W=2U AS=1.5P AD=1.5P PS=5.5U
+ PD=5.5U
M$54 \$1328 CLK VDD VDD pfet_03v3 L=0.28U W=2U AS=1.5P AD=1.5P PS=5.5U PD=5.5U
M$55 \$1265 CLK VDD VDD pfet_03v3 L=0.28U W=2U AS=1.5P AD=1.5P PS=5.5U PD=5.5U
M$56 \$1265 \$1332 VDD VDD pfet_03v3 L=0.28U W=2U AS=1.5P AD=1.5P PS=5.5U
+ PD=5.5U
M$57 \$1329 \$1265 VDD VDD pfet_03v3 L=0.28U W=2U AS=1.5P AD=1.5P PS=5.5U
+ PD=5.5U
M$58 \$1330 \$1329 VDD VDD pfet_03v3 L=0.28U W=2U AS=1.5P AD=1.5P PS=5.5U
+ PD=5.5U
M$59 \$741 \$1330 VDD VDD pfet_03v3 L=0.28U W=2U AS=1.5P AD=1.5P PS=5.5U PD=5.5U
M$60 \$1267 \$1330 VDD VDD pfet_03v3 L=0.28U W=2U AS=1.5P AD=1.5P PS=5.5U
+ PD=5.5U
M$61 \$1267 \$1328 VDD VDD pfet_03v3 L=0.28U W=2U AS=1.5P AD=1.5P PS=5.5U
+ PD=5.5U
M$62 \$1331 \$1267 VDD VDD pfet_03v3 L=0.28U W=2U AS=1.5P AD=1.5P PS=5.5U
+ PD=5.5U
M$63 \$1332 \$1331 VDD VDD pfet_03v3 L=0.28U W=2U AS=1.5P AD=1.5P PS=5.5U
+ PD=5.5U
M$64 \$742 \$1332 VDD VDD pfet_03v3 L=0.28U W=2U AS=1.5P AD=1.5P PS=5.5U PD=5.5U
M$66 \$2614 \$3604 \$3295 VDD pfet_03v3 L=0.28U W=150U AS=112.5P AD=112.5P
+ PS=315U PD=315U
M$76 \$3296 \$3603 \$3295 VDD pfet_03v3 L=0.28U W=150U AS=112.5P AD=112.5P
+ PS=315U PD=315U
M$88 \$3305 \$3609 VDD VDD pfet_03v3 L=6U W=0.65U AS=0.39P AD=0.39P PS=2.5U
+ PD=2.5U
M$90 \$3295 \$3600 VDD VDD pfet_03v3 L=2U W=8U AS=4.8P AD=4.8P PS=17.2U PD=17.2U
M$91 \$3609 \$3609 VDD VDD pfet_03v3 L=6U W=0.65U AS=0.39P AD=0.39P PS=2.5U
+ PD=2.5U
M$94 \$3603 \$742 \$3303 VDD pfet_03v3 L=0.28U W=4U AS=3P AD=3P PS=9.5U PD=9.5U
M$95 \$2552 \$742 \$3304 VDD pfet_03v3 L=0.28U W=4U AS=3P AD=3P PS=9.5U PD=9.5U
M$96 \$2552 \$741 \$2552 VDD pfet_03v3 L=0.28U W=2U AS=1.5P AD=1.5P PS=5.5U
+ PD=5.5U
M$97 \$3604 \$741 \$3303 VDD pfet_03v3 L=0.28U W=4U AS=3P AD=3P PS=9.5U PD=9.5U
M$98 \$1823 \$741 \$3304 VDD pfet_03v3 L=0.28U W=4U AS=3P AD=3P PS=9.5U PD=9.5U
M$99 \$1823 \$742 \$1823 VDD pfet_03v3 L=0.28U W=2U AS=1.5P AD=1.5P PS=5.5U
+ PD=5.5U
M$100 \$1823 \$742 \$3305 VDD pfet_03v3 L=0.28U W=4U AS=3P AD=3P PS=9.5U PD=9.5U
M$101 \$3604 \$742 \$3302 VDD pfet_03v3 L=0.28U W=4U AS=3P AD=3P PS=9.5U PD=9.5U
M$102 \$1823 \$741 \$1823 VDD pfet_03v3 L=0.28U W=2U AS=1.5P AD=1.5P PS=5.5U
+ PD=5.5U
M$103 \$2552 \$741 \$3305 VDD pfet_03v3 L=0.28U W=4U AS=3P AD=3P PS=9.5U PD=9.5U
M$104 \$3603 \$741 \$3302 VDD pfet_03v3 L=0.28U W=4U AS=3P AD=3P PS=9.5U PD=9.5U
M$105 \$2552 \$742 \$2552 VDD pfet_03v3 L=0.28U W=2U AS=1.5P AD=1.5P PS=5.5U
+ PD=5.5U
M$107 \$3600 \$3600 VDD VDD pfet_03v3 L=2U W=8U AS=4.8P AD=4.8P PS=17.2U
+ PD=17.2U
M$108 \$3614 \$3614 VDD VDD pfet_03v3 L=2U W=8U AS=4.8P AD=4.8P PS=17.2U
+ PD=17.2U
M$111 \$3617 \$3617 VDD VDD pfet_03v3 L=6U W=0.65U AS=0.39P AD=0.39P PS=2.5U
+ PD=2.5U
M$112 \$3304 \$3617 VDD VDD pfet_03v3 L=6U W=0.65U AS=0.39P AD=0.39P PS=2.5U
+ PD=2.5U
M$114 \$3603 \$741 \$3603 VDD pfet_03v3 L=0.28U W=2U AS=1.5P AD=1.5P PS=5.5U
+ PD=5.5U
M$115 \$3604 \$742 \$3604 VDD pfet_03v3 L=0.28U W=2U AS=1.5P AD=1.5P PS=5.5U
+ PD=5.5U
M$116 \$3604 \$741 \$3604 VDD pfet_03v3 L=0.28U W=2U AS=1.5P AD=1.5P PS=5.5U
+ PD=5.5U
M$117 \$3603 \$742 \$3603 VDD pfet_03v3 L=0.28U W=2U AS=1.5P AD=1.5P PS=5.5U
+ PD=5.5U
M$118 VSS VSS VSS VSS nfet_03v3 L=6U W=14.4U AS=8.352P AD=8.352P PS=38.08U
+ PD=38.08U
M$119 \$66 \$66 VSS VSS nfet_03v3 L=6U W=1.8U AS=1.08P AD=1.08P PS=4.8U PD=4.8U
M$120 \$1067 \$66 VSS VSS nfet_03v3 L=6U W=1.8U AS=1.08P AD=1.08P PS=4.8U
+ PD=4.8U
M$121 \$761 \$66 VSS VSS nfet_03v3 L=6U W=1.8U AS=1.08P AD=1.08P PS=4.8U PD=4.8U
M$124 \$762 \$752 VSS VSS nfet_03v3 L=6U W=1.8U AS=1.08P AD=1.08P PS=4.8U
+ PD=4.8U
M$125 \$1075 \$752 VSS VSS nfet_03v3 L=6U W=1.8U AS=1.08P AD=1.08P PS=4.8U
+ PD=4.8U
M$126 \$752 \$752 VSS VSS nfet_03v3 L=6U W=1.8U AS=1.08P AD=1.08P PS=4.8U
+ PD=4.8U
M$128 VOUTP \$741 \$761 VSS nfet_03v3 L=0.28U W=2U AS=1.5P AD=1.5P PS=5.5U
+ PD=5.5U
M$129 VOUTP \$742 VOUTP VSS nfet_03v3 L=0.28U W=1U AS=0.75P AD=0.75P PS=3.5U
+ PD=3.5U
M$130 VOUTN \$742 \$761 VSS nfet_03v3 L=0.28U W=2U AS=1.5P AD=1.5P PS=5.5U
+ PD=5.5U
M$131 VOUTN \$741 VOUTN VSS nfet_03v3 L=0.28U W=1U AS=0.75P AD=0.75P PS=3.5U
+ PD=3.5U
M$132 VOUTN \$741 \$762 VSS nfet_03v3 L=0.28U W=2U AS=1.5P AD=1.5P PS=5.5U
+ PD=5.5U
M$133 VOUTN \$742 VOUTN VSS nfet_03v3 L=0.28U W=1U AS=0.75P AD=0.75P PS=3.5U
+ PD=3.5U
M$134 VOUTP \$742 \$762 VSS nfet_03v3 L=0.28U W=2U AS=1.5P AD=1.5P PS=5.5U
+ PD=5.5U
M$135 VOUTP \$741 VOUTP VSS nfet_03v3 L=0.28U W=1U AS=0.75P AD=0.75P PS=3.5U
+ PD=3.5U
M$136 VSS VSS VSS VSS nfet_03v3 L=2U W=32U AS=18.56P AD=18.56P PS=80.24U
+ PD=80.24U
M$138 \$1058 \$762 \$1057 VSS nfet_03v3 L=2U W=1.6U AS=0.96P AD=0.96P PS=4.4U
+ PD=4.4U
M$139 \$765 IB VSS VSS nfet_03v3 L=2U W=3.2U AS=1.92P AD=1.92P PS=7.6U PD=7.6U
M$140 \$1072 VCM \$1057 VSS nfet_03v3 L=2U W=1.6U AS=0.96P AD=0.96P PS=4.4U
+ PD=4.4U
M$141 \$1057 IB VSS VSS nfet_03v3 L=2U W=3.2U AS=1.92P AD=1.92P PS=7.6U PD=7.6U
M$145 \$1058 \$761 \$765 VSS nfet_03v3 L=2U W=1.6U AS=0.96P AD=0.96P PS=4.4U
+ PD=4.4U
M$146 \$1072 VCM \$765 VSS nfet_03v3 L=2U W=1.6U AS=0.96P AD=0.96P PS=4.4U
+ PD=4.4U
M$148 \$1061 \$741 \$760 VSS nfet_03v3 L=0.28U W=2U AS=1.5P AD=1.5P PS=5.5U
+ PD=5.5U
M$149 \$1061 \$742 \$1061 VSS nfet_03v3 L=0.28U W=1U AS=0.75P AD=0.75P PS=3.5U
+ PD=3.5U
M$150 \$1062 \$742 \$760 VSS nfet_03v3 L=0.28U W=2U AS=1.5P AD=1.5P PS=5.5U
+ PD=5.5U
M$151 \$1062 \$741 \$1062 VSS nfet_03v3 L=0.28U W=1U AS=0.75P AD=0.75P PS=3.5U
+ PD=3.5U
M$152 \$1062 \$741 \$759 VSS nfet_03v3 L=0.28U W=2U AS=1.5P AD=1.5P PS=5.5U
+ PD=5.5U
M$153 \$1062 \$742 \$1062 VSS nfet_03v3 L=0.28U W=1U AS=0.75P AD=0.75P PS=3.5U
+ PD=3.5U
M$154 \$1061 \$742 \$759 VSS nfet_03v3 L=0.28U W=2U AS=1.5P AD=1.5P PS=5.5U
+ PD=5.5U
M$155 \$1061 \$741 \$1061 VSS nfet_03v3 L=0.28U W=1U AS=0.75P AD=0.75P PS=3.5U
+ PD=3.5U
M$156 \$1328 CLK VSS VSS nfet_03v3 L=0.28U W=1U AS=0.75P AD=0.75P PS=3.5U
+ PD=3.5U
M$157 \$1265 CLK \$1264 VSS nfet_03v3 L=0.28U W=2U AS=1.5P AD=1.5P PS=5.5U
+ PD=5.5U
M$158 \$1264 \$1332 VSS VSS nfet_03v3 L=0.28U W=2U AS=1.5P AD=1.5P PS=5.5U
+ PD=5.5U
M$159 \$1329 \$1265 VSS VSS nfet_03v3 L=0.28U W=1U AS=0.75P AD=0.75P PS=3.5U
+ PD=3.5U
M$160 \$1330 \$1329 VSS VSS nfet_03v3 L=0.28U W=1U AS=0.75P AD=0.75P PS=3.5U
+ PD=3.5U
M$161 \$741 \$1330 VSS VSS nfet_03v3 L=0.28U W=1U AS=0.75P AD=0.75P PS=3.5U
+ PD=3.5U
M$162 \$1267 \$1330 \$1266 VSS nfet_03v3 L=0.28U W=2U AS=1.5P AD=1.5P PS=5.5U
+ PD=5.5U
M$163 \$1266 \$1328 VSS VSS nfet_03v3 L=0.28U W=2U AS=1.5P AD=1.5P PS=5.5U
+ PD=5.5U
M$164 \$1331 \$1267 VSS VSS nfet_03v3 L=0.28U W=1U AS=0.75P AD=0.75P PS=3.5U
+ PD=3.5U
M$165 \$1332 \$1331 VSS VSS nfet_03v3 L=0.28U W=1U AS=0.75P AD=0.75P PS=3.5U
+ PD=3.5U
M$166 \$742 \$1332 VSS VSS nfet_03v3 L=0.28U W=1U AS=0.75P AD=0.75P PS=3.5U
+ PD=3.5U
M$169 \$3305 \$3296 VSS VSS nfet_03v3 L=6U W=1.8U AS=1.08P AD=1.08P PS=4.8U
+ PD=4.8U
M$170 \$2614 \$2614 VSS VSS nfet_03v3 L=6U W=1.8U AS=1.08P AD=1.08P PS=4.8U
+ PD=4.8U
M$171 \$3609 \$2614 VSS VSS nfet_03v3 L=6U W=1.8U AS=1.08P AD=1.08P PS=4.8U
+ PD=4.8U
M$172 \$3617 \$3296 VSS VSS nfet_03v3 L=6U W=1.8U AS=1.08P AD=1.08P PS=4.8U
+ PD=4.8U
M$173 \$3296 \$3296 VSS VSS nfet_03v3 L=6U W=1.8U AS=1.08P AD=1.08P PS=4.8U
+ PD=4.8U
M$174 \$3304 \$2614 VSS VSS nfet_03v3 L=6U W=1.8U AS=1.08P AD=1.08P PS=4.8U
+ PD=4.8U
M$178 IB IB VSS VSS nfet_03v3 L=2U W=3.2U AS=1.92P AD=1.92P PS=7.6U PD=7.6U
M$180 \$2552 \$741 \$3304 VSS nfet_03v3 L=0.28U W=2U AS=1.5P AD=1.5P PS=5.5U
+ PD=5.5U
M$181 \$2552 \$742 \$2552 VSS nfet_03v3 L=0.28U W=1U AS=0.75P AD=0.75P PS=3.5U
+ PD=3.5U
M$182 \$1823 \$742 \$3304 VSS nfet_03v3 L=0.28U W=2U AS=1.5P AD=1.5P PS=5.5U
+ PD=5.5U
M$183 \$1823 \$741 \$1823 VSS nfet_03v3 L=0.28U W=1U AS=0.75P AD=0.75P PS=3.5U
+ PD=3.5U
M$184 \$1823 \$741 \$3305 VSS nfet_03v3 L=0.28U W=2U AS=1.5P AD=1.5P PS=5.5U
+ PD=5.5U
M$185 \$1823 \$742 \$1823 VSS nfet_03v3 L=0.28U W=1U AS=0.75P AD=0.75P PS=3.5U
+ PD=3.5U
M$186 \$2552 \$742 \$3305 VSS nfet_03v3 L=0.28U W=2U AS=1.5P AD=1.5P PS=5.5U
+ PD=5.5U
M$187 \$2552 \$741 \$2552 VSS nfet_03v3 L=0.28U W=1U AS=0.75P AD=0.75P PS=3.5U
+ PD=3.5U
M$190 \$3600 \$3305 \$3599 VSS nfet_03v3 L=2U W=1.6U AS=0.96P AD=0.96P PS=4.4U
+ PD=4.4U
M$191 \$3308 IB VSS VSS nfet_03v3 L=2U W=3.2U AS=1.92P AD=1.92P PS=7.6U PD=7.6U
M$192 \$3614 VCM \$3599 VSS nfet_03v3 L=2U W=1.6U AS=0.96P AD=0.96P PS=4.4U
+ PD=4.4U
M$193 \$3599 IB VSS VSS nfet_03v3 L=2U W=3.2U AS=1.92P AD=1.92P PS=7.6U PD=7.6U
M$197 \$3600 \$3304 \$3308 VSS nfet_03v3 L=2U W=1.6U AS=0.96P AD=0.96P PS=4.4U
+ PD=4.4U
M$198 \$3614 VCM \$3308 VSS nfet_03v3 L=2U W=1.6U AS=0.96P AD=0.96P PS=4.4U
+ PD=4.4U
M$200 \$3603 \$741 \$3303 VSS nfet_03v3 L=0.28U W=2U AS=1.5P AD=1.5P PS=5.5U
+ PD=5.5U
M$201 \$3603 \$742 \$3603 VSS nfet_03v3 L=0.28U W=1U AS=0.75P AD=0.75P PS=3.5U
+ PD=3.5U
M$202 \$3604 \$742 \$3303 VSS nfet_03v3 L=0.28U W=2U AS=1.5P AD=1.5P PS=5.5U
+ PD=5.5U
M$203 \$3604 \$741 \$3604 VSS nfet_03v3 L=0.28U W=1U AS=0.75P AD=0.75P PS=3.5U
+ PD=3.5U
M$204 \$3604 \$741 \$3302 VSS nfet_03v3 L=0.28U W=2U AS=1.5P AD=1.5P PS=5.5U
+ PD=5.5U
M$205 \$3604 \$742 \$3604 VSS nfet_03v3 L=0.28U W=1U AS=0.75P AD=0.75P PS=3.5U
+ PD=3.5U
M$206 \$3603 \$742 \$3302 VSS nfet_03v3 L=0.28U W=2U AS=1.5P AD=1.5P PS=5.5U
+ PD=5.5U
M$207 \$3603 \$741 \$3603 VSS nfet_03v3 L=0.28U W=1U AS=0.75P AD=0.75P PS=3.5U
+ PD=3.5U
M$208 \$430 VG VG VG nfet_03v3 L=5U W=0.5U AS=0.3P AD=0.3P PS=2.2U PD=2.2U
M$209 VOUTN \$248 \$248 \$248 nfet_03v3 L=12U W=0.5U AS=0.3P AD=0.3P PS=2.2U
+ PD=2.2U
M$210 \$759 VG VG VG nfet_03v3 L=5U W=0.5U AS=0.3P AD=0.3P PS=2.2U PD=2.2U
M$211 \$430 \$248 \$248 \$248 nfet_03v3 L=12U W=0.5U AS=0.3P AD=0.3P PS=2.2U
+ PD=2.2U
M$212 \$1060 VG VG VG nfet_03v3 L=5U W=0.5U AS=0.3P AD=0.3P PS=2.2U PD=2.2U
M$213 VOUTP \$1059 \$1059 \$1059 nfet_03v3 L=12U W=0.5U AS=0.3P AD=0.3P PS=2.2U
+ PD=2.2U
M$214 \$760 VG VG VG nfet_03v3 L=5U W=0.5U AS=0.3P AD=0.3P PS=2.2U PD=2.2U
M$215 \$1060 \$1059 \$1059 \$1059 nfet_03v3 L=12U W=0.5U AS=0.3P AD=0.3P
+ PS=2.2U PD=2.2U
M$216 \$2977 VG VG VG nfet_03v3 L=5U W=0.5U AS=0.3P AD=0.3P PS=2.2U PD=2.2U
M$217 \$1823 \$2795 \$2795 \$2795 nfet_03v3 L=12U W=0.5U AS=0.3P AD=0.3P
+ PS=2.2U PD=2.2U
M$218 \$3302 VG VG VG nfet_03v3 L=5U W=0.5U AS=0.3P AD=0.3P PS=2.2U PD=2.2U
M$219 \$2977 \$2795 \$2795 \$2795 nfet_03v3 L=12U W=0.5U AS=0.3P AD=0.3P
+ PS=2.2U PD=2.2U
M$220 \$3602 VG VG VG nfet_03v3 L=5U W=0.5U AS=0.3P AD=0.3P PS=2.2U PD=2.2U
M$221 \$2552 \$3601 \$3601 \$3601 nfet_03v3 L=12U W=0.5U AS=0.3P AD=0.3P
+ PS=2.2U PD=2.2U
M$222 \$3303 VG VG VG nfet_03v3 L=5U W=0.5U AS=0.3P AD=0.3P PS=2.2U PD=2.2U
M$223 \$3602 \$3601 \$3601 \$3601 nfet_03v3 L=12U W=0.5U AS=0.3P AD=0.3P
+ PS=2.2U PD=2.2U
C$224 \$3302 VINN 4e-12 cap_mim_2f0fF A=2000P P=400U
C$228 \$759 \$1823 1e-12 cap_mim_2f0fF A=500P P=200U
C$230 \$760 \$2552 1e-12 cap_mim_2f0fF A=500P P=200U
C$231 VOUTP \$760 2e-13 cap_mim_2f0fF A=100P P=40U
C$233 VOUTN VOUTP 1e-12 cap_mim_2f0fF A=500P P=200U
C$235 \$1823 \$2552 1e-12 cap_mim_2f0fF A=500P P=200U
C$243 VOUTN \$759 2e-13 cap_mim_2f0fF A=100P P=40U
C$249 \$1823 \$3302 2e-13 cap_mim_2f0fF A=100P P=40U
C$250 \$2552 \$3303 2e-13 cap_mim_2f0fF A=100P P=40U
C$251 \$3303 VINP 4e-12 cap_mim_2f0fF A=2000P P=400U
.ENDS ina
