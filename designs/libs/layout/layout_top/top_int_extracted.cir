* Extracted by KLayout with GF180MCU LVS runset on : 30/08/2026 18:28

.SUBCKT top_int Vcm 1ua Vb0V94 swm8 swm1 swm2 outn vn outp inn inp VDD3V3 sw0
+ swm4 swm16 VB1V3|Vb1V3 voutn voutp vp VG IB CLK VINP VINN VSS
M$1 \$86 \$183 VDD3V3 VDD3V3 pfet_03v3 L=1U W=4.9U AS=2.94P AD=2.94P PS=11U
+ PD=11U
M$2 \$130 \$130 VDD3V3 VDD3V3 pfet_03v3 L=1U W=3U AS=1.8P AD=1.8P PS=7.2U
+ PD=7.2U
M$3 \$131 \$131 VDD3V3 VDD3V3 pfet_03v3 L=1U W=3U AS=1.8P AD=1.8P PS=7.2U
+ PD=7.2U
M$4 \$133 \$133 VDD3V3 VDD3V3 pfet_03v3 L=1U W=3U AS=1.8P AD=1.8P PS=7.2U
+ PD=7.2U
M$5 \$183 \$183 VDD3V3 VDD3V3 pfet_03v3 L=1U W=6U AS=3.6P AD=3.6P PS=13.2U
+ PD=13.2U
M$6 voutn \$453 VDD3V3 VDD3V3 pfet_03v3 L=1U W=6U AS=2P AD=2P PS=11U PD=11U
M$12 \$453 \$453 VDD3V3 VDD3V3 pfet_03v3 L=1U W=6U AS=2P AD=2P PS=11U PD=11U
M$18 \$295 \$183 VDD3V3 VDD3V3 pfet_03v3 L=1U W=11U AS=6.6P AD=6.6P PS=23.2U
+ PD=23.2U
M$19 \$385 VB1V3|Vb1V3 outn VDD3V3 pfet_03v3 L=1U W=4U AS=2.4P AD=2.4P PS=9.2U
+ PD=9.2U
M$20 \$296 inp \$515 VDD3V3 pfet_03v3 L=1U W=10U AS=6P AD=6P PS=21.2U PD=21.2U
M$21 \$297 inn \$515 VDD3V3 pfet_03v3 L=1U W=10U AS=6P AD=6P PS=21.2U PD=21.2U
M$22 outp VB1V3|Vb1V3 \$386 VDD3V3 pfet_03v3 L=1U W=4U AS=2.4P AD=2.4P PS=9.2U
+ PD=9.2U
M$23 \$424 \$424 VDD3V3 VDD3V3 pfet_03v3 L=1U W=6U AS=2P AD=2P PS=11U PD=11U
M$29 voutp \$424 VDD3V3 VDD3V3 pfet_03v3 L=1U W=6U AS=2P AD=2P PS=11U PD=11U
M$35 \$190 swm8 VDD3V3 VDD3V3 pfet_03v3 L=0.36U W=12U AS=5.28P AD=5.28P
+ PS=19.76U PD=19.76U
M$37 \$206 swm1 VDD3V3 VDD3V3 pfet_03v3 L=0.36U W=12U AS=5.28P AD=5.28P
+ PS=19.76U PD=19.76U
M$39 \$228 swm2 VDD3V3 VDD3V3 pfet_03v3 L=0.36U W=12U AS=5.28P AD=5.28P
+ PS=19.76U PD=19.76U
M$41 \$223 swm2 VDD3V3 VDD3V3 pfet_03v3 L=0.36U W=12U AS=5.28P AD=5.28P
+ PS=19.76U PD=19.76U
M$43 \$210 swm1 VDD3V3 VDD3V3 pfet_03v3 L=0.36U W=12U AS=5.28P AD=5.28P
+ PS=19.76U PD=19.76U
M$45 \$195 swm8 VDD3V3 VDD3V3 pfet_03v3 L=0.36U W=12U AS=5.28P AD=5.28P
+ PS=19.76U PD=19.76U
M$47 VDD3V3 VDD3V3 VDD3V3 VDD3V3 pfet_03v3 L=0.28U W=60U AS=43.8P AD=43.8P
+ PS=125.84U PD=125.84U
M$48 \$758 \$1754 \$1443 VDD3V3 pfet_03v3 L=0.28U W=150U AS=112.5P AD=112.5P
+ PS=315U PD=315U
M$58 \$1444 \$1753 \$1443 VDD3V3 pfet_03v3 L=0.28U W=150U AS=112.5P AD=112.5P
+ PS=315U PD=315U
M$60 \$385 \$131 VDD3V3 VDD3V3 pfet_03v3 L=1U W=4U AS=2.4P AD=2.4P PS=9.2U
+ PD=9.2U
M$64 \$515 \$183 VDD3V3 VDD3V3 pfet_03v3 L=1U W=32U AS=19.2P AD=19.2P PS=65.2U
+ PD=65.2U
M$67 VDD3V3 \$131 \$386 VDD3V3 pfet_03v3 L=1U W=4U AS=2.4P AD=2.4P PS=9.2U
+ PD=9.2U
M$72 \$451 sw0 VDD3V3 VDD3V3 pfet_03v3 L=0.36U W=12U AS=5.28P AD=5.28P
+ PS=19.76U PD=19.76U
M$74 \$450 swm4 VDD3V3 VDD3V3 pfet_03v3 L=0.36U W=12U AS=5.28P AD=5.28P
+ PS=19.76U PD=19.76U
M$76 \$449 swm16 VDD3V3 VDD3V3 pfet_03v3 L=0.36U W=12U AS=5.28P AD=5.28P
+ PS=19.76U PD=19.76U
M$78 \$445 sw0 VDD3V3 VDD3V3 pfet_03v3 L=0.36U W=12U AS=5.28P AD=5.28P
+ PS=19.76U PD=19.76U
M$80 \$446 swm4 VDD3V3 VDD3V3 pfet_03v3 L=0.36U W=12U AS=5.28P AD=5.28P
+ PS=19.76U PD=19.76U
M$82 \$447 swm16 VDD3V3 VDD3V3 pfet_03v3 L=0.36U W=12U AS=5.28P AD=5.28P
+ PS=19.76U PD=19.76U
M$84 VDD3V3 VDD3V3 VDD3V3 VDD3V3 pfet_03v3 L=6U W=5.2U AS=3.016P AD=3.016P
+ PS=19.68U PD=19.68U
M$85 \$1454 \$1759 VDD3V3 VDD3V3 pfet_03v3 L=6U W=0.65U AS=0.39P AD=0.39P
+ PS=2.5U PD=2.5U
M$86 VDD3V3 VDD3V3 VDD3V3 VDD3V3 pfet_03v3 L=2U W=64U AS=37.12P AD=37.12P
+ PS=137.28U PD=137.28U
M$87 \$1443 \$1750 VDD3V3 VDD3V3 pfet_03v3 L=2U W=8U AS=4.8P AD=4.8P PS=17.2U
+ PD=17.2U
M$88 \$1759 \$1759 VDD3V3 VDD3V3 pfet_03v3 L=6U W=0.65U AS=0.39P AD=0.39P
+ PS=2.5U PD=2.5U
M$91 \$1753 \$1434 \$1452 VDD3V3 pfet_03v3 L=0.28U W=4U AS=3P AD=3P PS=9.5U
+ PD=9.5U
M$92 vp \$1434 \$1453 VDD3V3 pfet_03v3 L=0.28U W=4U AS=3P AD=3P PS=9.5U PD=9.5U
M$93 vp \$1433 vp VDD3V3 pfet_03v3 L=0.28U W=2U AS=1.5P AD=1.5P PS=5.5U PD=5.5U
M$94 \$1754 \$1433 \$1452 VDD3V3 pfet_03v3 L=0.28U W=4U AS=3P AD=3P PS=9.5U
+ PD=9.5U
M$95 vn \$1433 \$1453 VDD3V3 pfet_03v3 L=0.28U W=4U AS=3P AD=3P PS=9.5U PD=9.5U
M$96 vn \$1434 vn VDD3V3 pfet_03v3 L=0.28U W=2U AS=1.5P AD=1.5P PS=5.5U PD=5.5U
M$97 vn \$1434 \$1454 VDD3V3 pfet_03v3 L=0.28U W=4U AS=3P AD=3P PS=9.5U PD=9.5U
M$98 \$1754 \$1434 \$1451 VDD3V3 pfet_03v3 L=0.28U W=4U AS=3P AD=3P PS=9.5U
+ PD=9.5U
M$99 vn \$1433 vn VDD3V3 pfet_03v3 L=0.28U W=2U AS=1.5P AD=1.5P PS=5.5U PD=5.5U
M$100 vp \$1433 \$1454 VDD3V3 pfet_03v3 L=0.28U W=4U AS=3P AD=3P PS=9.5U PD=9.5U
M$101 \$1753 \$1433 \$1451 VDD3V3 pfet_03v3 L=0.28U W=4U AS=3P AD=3P PS=9.5U
+ PD=9.5U
M$102 vp \$1434 vp VDD3V3 pfet_03v3 L=0.28U W=2U AS=1.5P AD=1.5P PS=5.5U PD=5.5U
M$104 \$1750 \$1750 VDD3V3 VDD3V3 pfet_03v3 L=2U W=8U AS=4.8P AD=4.8P PS=17.2U
+ PD=17.2U
M$105 \$1764 \$1764 VDD3V3 VDD3V3 pfet_03v3 L=2U W=8U AS=4.8P AD=4.8P PS=17.2U
+ PD=17.2U
M$108 \$1769 \$1769 VDD3V3 VDD3V3 pfet_03v3 L=6U W=0.65U AS=0.39P AD=0.39P
+ PS=2.5U PD=2.5U
M$109 \$1453 \$1769 VDD3V3 VDD3V3 pfet_03v3 L=6U W=0.65U AS=0.39P AD=0.39P
+ PS=2.5U PD=2.5U
M$111 \$1753 \$1433 \$1753 VDD3V3 pfet_03v3 L=0.28U W=2U AS=1.5P AD=1.5P
+ PS=5.5U PD=5.5U
M$112 \$1754 \$1434 \$1754 VDD3V3 pfet_03v3 L=0.28U W=2U AS=1.5P AD=1.5P
+ PS=5.5U PD=5.5U
M$113 \$1754 \$1433 \$1754 VDD3V3 pfet_03v3 L=0.28U W=2U AS=1.5P AD=1.5P
+ PS=5.5U PD=5.5U
M$114 \$1753 \$1434 \$1753 VDD3V3 pfet_03v3 L=0.28U W=2U AS=1.5P AD=1.5P
+ PS=5.5U PD=5.5U
M$115 \$1956 CLK VDD3V3 VDD3V3 pfet_03v3 L=0.28U W=2U AS=1.5P AD=1.5P PS=5.5U
+ PD=5.5U
M$116 \$1958 CLK VDD3V3 VDD3V3 pfet_03v3 L=0.28U W=2U AS=1.5P AD=1.5P PS=5.5U
+ PD=5.5U
M$117 \$1958 \$1964 VDD3V3 VDD3V3 pfet_03v3 L=0.28U W=2U AS=1.5P AD=1.5P
+ PS=5.5U PD=5.5U
M$118 \$1959 \$1958 VDD3V3 VDD3V3 pfet_03v3 L=0.28U W=2U AS=1.5P AD=1.5P
+ PS=5.5U PD=5.5U
M$119 \$1960 \$1959 VDD3V3 VDD3V3 pfet_03v3 L=0.28U W=2U AS=1.5P AD=1.5P
+ PS=5.5U PD=5.5U
M$120 \$1433 \$1960 VDD3V3 VDD3V3 pfet_03v3 L=0.28U W=2U AS=1.5P AD=1.5P
+ PS=5.5U PD=5.5U
M$121 \$1962 \$1960 VDD3V3 VDD3V3 pfet_03v3 L=0.28U W=2U AS=1.5P AD=1.5P
+ PS=5.5U PD=5.5U
M$122 \$1962 \$1956 VDD3V3 VDD3V3 pfet_03v3 L=0.28U W=2U AS=1.5P AD=1.5P
+ PS=5.5U PD=5.5U
M$123 \$1963 \$1962 VDD3V3 VDD3V3 pfet_03v3 L=0.28U W=2U AS=1.5P AD=1.5P
+ PS=5.5U PD=5.5U
M$124 \$1964 \$1963 VDD3V3 VDD3V3 pfet_03v3 L=0.28U W=2U AS=1.5P AD=1.5P
+ PS=5.5U PD=5.5U
M$125 \$1434 \$1964 VDD3V3 VDD3V3 pfet_03v3 L=0.28U W=2U AS=1.5P AD=1.5P
+ PS=5.5U PD=5.5U
M$127 \$3306 \$4296 \$3987 VDD3V3 pfet_03v3 L=0.28U W=150U AS=112.5P AD=112.5P
+ PS=315U PD=315U
M$137 \$3988 \$4295 \$3987 VDD3V3 pfet_03v3 L=0.28U W=150U AS=112.5P AD=112.5P
+ PS=315U PD=315U
M$149 \$3997 \$4301 VDD3V3 VDD3V3 pfet_03v3 L=6U W=0.65U AS=0.39P AD=0.39P
+ PS=2.5U PD=2.5U
M$151 \$3987 \$4292 VDD3V3 VDD3V3 pfet_03v3 L=2U W=8U AS=4.8P AD=4.8P PS=17.2U
+ PD=17.2U
M$152 \$4301 \$4301 VDD3V3 VDD3V3 pfet_03v3 L=6U W=0.65U AS=0.39P AD=0.39P
+ PS=2.5U PD=2.5U
M$155 \$3245 \$1434 \$3996 VDD3V3 pfet_03v3 L=0.28U W=4U AS=3P AD=3P PS=9.5U
+ PD=9.5U
M$156 \$4295 \$1434 \$3995 VDD3V3 pfet_03v3 L=0.28U W=4U AS=3P AD=3P PS=9.5U
+ PD=9.5U
M$157 \$3245 \$1433 \$3245 VDD3V3 pfet_03v3 L=0.28U W=2U AS=1.5P AD=1.5P
+ PS=5.5U PD=5.5U
M$158 \$4296 \$1433 \$3995 VDD3V3 pfet_03v3 L=0.28U W=4U AS=3P AD=3P PS=9.5U
+ PD=9.5U
M$159 \$2514 \$1433 \$3996 VDD3V3 pfet_03v3 L=0.28U W=4U AS=3P AD=3P PS=9.5U
+ PD=9.5U
M$160 \$2514 \$1434 \$2514 VDD3V3 pfet_03v3 L=0.28U W=2U AS=1.5P AD=1.5P
+ PS=5.5U PD=5.5U
M$161 \$2514 \$1434 \$3997 VDD3V3 pfet_03v3 L=0.28U W=4U AS=3P AD=3P PS=9.5U
+ PD=9.5U
M$162 \$4296 \$1434 \$3994 VDD3V3 pfet_03v3 L=0.28U W=4U AS=3P AD=3P PS=9.5U
+ PD=9.5U
M$163 \$2514 \$1433 \$2514 VDD3V3 pfet_03v3 L=0.28U W=2U AS=1.5P AD=1.5P
+ PS=5.5U PD=5.5U
M$164 \$3245 \$1433 \$3997 VDD3V3 pfet_03v3 L=0.28U W=4U AS=3P AD=3P PS=9.5U
+ PD=9.5U
M$165 \$4295 \$1433 \$3994 VDD3V3 pfet_03v3 L=0.28U W=4U AS=3P AD=3P PS=9.5U
+ PD=9.5U
M$166 \$3245 \$1434 \$3245 VDD3V3 pfet_03v3 L=0.28U W=2U AS=1.5P AD=1.5P
+ PS=5.5U PD=5.5U
M$168 \$4292 \$4292 VDD3V3 VDD3V3 pfet_03v3 L=2U W=8U AS=4.8P AD=4.8P PS=17.2U
+ PD=17.2U
M$169 \$4306 \$4306 VDD3V3 VDD3V3 pfet_03v3 L=2U W=8U AS=4.8P AD=4.8P PS=17.2U
+ PD=17.2U
M$172 \$4309 \$4309 VDD3V3 VDD3V3 pfet_03v3 L=6U W=0.65U AS=0.39P AD=0.39P
+ PS=2.5U PD=2.5U
M$173 \$3996 \$4309 VDD3V3 VDD3V3 pfet_03v3 L=6U W=0.65U AS=0.39P AD=0.39P
+ PS=2.5U PD=2.5U
M$175 \$4295 \$1433 \$4295 VDD3V3 pfet_03v3 L=0.28U W=2U AS=1.5P AD=1.5P
+ PS=5.5U PD=5.5U
M$176 \$4296 \$1434 \$4296 VDD3V3 pfet_03v3 L=0.28U W=2U AS=1.5P AD=1.5P
+ PS=5.5U PD=5.5U
M$177 \$4296 \$1433 \$4296 VDD3V3 pfet_03v3 L=0.28U W=2U AS=1.5P AD=1.5P
+ PS=5.5U PD=5.5U
M$178 \$4295 \$1434 \$4295 VDD3V3 pfet_03v3 L=0.28U W=2U AS=1.5P AD=1.5P
+ PS=5.5U PD=5.5U
M$179 \$129 \$86 VSS VSS nfet_03v3 L=1U W=8U AS=4.8P AD=4.8P PS=17.2U PD=17.2U
M$180 \$86 \$86 VSS VSS nfet_03v3 L=1U W=8U AS=4.8P AD=4.8P PS=17.2U PD=17.2U
M$181 \$132 \$86 VSS VSS nfet_03v3 L=1U W=8U AS=4.8P AD=4.8P PS=17.2U PD=17.2U
M$182 \$130 outp \$129 VSS nfet_03v3 L=1U W=10U AS=6P AD=6P PS=21.2U PD=21.2U
M$183 \$131 Vcm \$129 VSS nfet_03v3 L=1U W=10U AS=6P AD=6P PS=21.2U PD=21.2U
M$184 \$131 Vcm \$132 VSS nfet_03v3 L=1U W=10U AS=6P AD=6P PS=21.2U PD=21.2U
M$185 \$133 outn \$132 VSS nfet_03v3 L=1U W=10U AS=6P AD=6P PS=21.2U PD=21.2U
M$186 1ua 1ua VSS VSS nfet_03v3 L=1U W=1U AS=0.6P AD=0.6P PS=3.2U PD=3.2U
M$187 \$295 \$295 VSS VSS nfet_03v3 L=1U W=4U AS=2.4P AD=2.4P PS=9.2U PD=9.2U
M$188 \$183 1ua VSS VSS nfet_03v3 L=1U W=3U AS=1.8P AD=1.8P PS=7.2U PD=7.2U
M$189 \$296 Vb0V94 outn VSS nfet_03v3 L=1U W=4U AS=2.4P AD=2.4P PS=9.2U PD=9.2U
M$190 \$296 \$295 VSS VSS nfet_03v3 L=1U W=9U AS=5.4P AD=5.4P PS=19.2U PD=19.2U
M$191 outp Vb0V94 \$297 VSS nfet_03v3 L=1U W=4U AS=2.4P AD=2.4P PS=9.2U PD=9.2U
M$192 VSS \$295 \$297 VSS nfet_03v3 L=1U W=9U AS=5.4P AD=5.4P PS=19.2U PD=19.2U
M$193 \$195 swm8 VSS VSS nfet_03v3 L=0.36U W=6U AS=2.64P AD=2.64P PS=10.76U
+ PD=10.76U
M$195 \$210 swm1 VSS VSS nfet_03v3 L=0.36U W=6U AS=2.64P AD=2.64P PS=10.76U
+ PD=10.76U
M$197 \$223 swm2 VSS VSS nfet_03v3 L=0.36U W=6U AS=2.64P AD=2.64P PS=10.76U
+ PD=10.76U
M$199 \$190 swm8 VSS VSS nfet_03v3 L=0.36U W=6U AS=2.64P AD=2.64P PS=10.76U
+ PD=10.76U
M$201 \$206 swm1 VSS VSS nfet_03v3 L=0.36U W=6U AS=2.64P AD=2.64P PS=10.76U
+ PD=10.76U
M$203 \$228 swm2 VSS VSS nfet_03v3 L=0.36U W=6U AS=2.64P AD=2.64P PS=10.76U
+ PD=10.76U
M$205 \$371 1ua VSS VSS nfet_03v3 L=1U W=10U AS=3.12P AD=3.12P PS=17.24U
+ PD=17.24U
M$215 \$374 1ua VSS VSS nfet_03v3 L=1U W=10U AS=3.12P AD=3.12P PS=17.24U
+ PD=17.24U
M$225 voutn voutn \$371 VSS nfet_03v3 L=1U W=6U AS=2P AD=2P PS=11U PD=11U
M$231 \$453 outn \$371 VSS nfet_03v3 L=1U W=6U AS=2P AD=2P PS=11U PD=11U
M$237 \$424 outp \$374 VSS nfet_03v3 L=1U W=6U AS=2P AD=2P PS=11U PD=11U
M$243 voutp voutp \$374 VSS nfet_03v3 L=1U W=6U AS=2P AD=2P PS=11U PD=11U
M$249 VSS VSS VSS VSS nfet_03v3 L=6U W=14.4U AS=8.352P AD=8.352P PS=38.08U
+ PD=38.08U
M$251 \$1454 \$1444 VSS VSS nfet_03v3 L=6U W=1.8U AS=1.08P AD=1.08P PS=4.8U
+ PD=4.8U
M$252 \$758 \$758 VSS VSS nfet_03v3 L=6U W=1.8U AS=1.08P AD=1.08P PS=4.8U
+ PD=4.8U
M$253 \$1769 \$1444 VSS VSS nfet_03v3 L=6U W=1.8U AS=1.08P AD=1.08P PS=4.8U
+ PD=4.8U
M$254 \$1759 \$758 VSS VSS nfet_03v3 L=6U W=1.8U AS=1.08P AD=1.08P PS=4.8U
+ PD=4.8U
M$255 \$1453 \$758 VSS VSS nfet_03v3 L=6U W=1.8U AS=1.08P AD=1.08P PS=4.8U
+ PD=4.8U
M$256 \$1444 \$1444 VSS VSS nfet_03v3 L=6U W=1.8U AS=1.08P AD=1.08P PS=4.8U
+ PD=4.8U
M$259 \$451 sw0 VSS VSS nfet_03v3 L=0.36U W=6U AS=2.64P AD=2.64P PS=10.76U
+ PD=10.76U
M$261 \$450 swm4 VSS VSS nfet_03v3 L=0.36U W=6U AS=2.64P AD=2.64P PS=10.76U
+ PD=10.76U
M$263 \$449 swm16 VSS VSS nfet_03v3 L=0.36U W=6U AS=2.64P AD=2.64P PS=10.76U
+ PD=10.76U
M$265 \$447 swm16 VSS VSS nfet_03v3 L=0.36U W=6U AS=2.64P AD=2.64P PS=10.76U
+ PD=10.76U
M$267 \$446 swm4 VSS VSS nfet_03v3 L=0.36U W=6U AS=2.64P AD=2.64P PS=10.76U
+ PD=10.76U
M$269 \$445 sw0 VSS VSS nfet_03v3 L=0.36U W=6U AS=2.64P AD=2.64P PS=10.76U
+ PD=10.76U
M$271 vp \$1433 \$1453 VSS nfet_03v3 L=0.28U W=2U AS=1.5P AD=1.5P PS=5.5U
+ PD=5.5U
M$272 vp \$1434 vp VSS nfet_03v3 L=0.28U W=1U AS=0.75P AD=0.75P PS=3.5U PD=3.5U
M$273 vn \$1434 \$1453 VSS nfet_03v3 L=0.28U W=2U AS=1.5P AD=1.5P PS=5.5U
+ PD=5.5U
M$274 vn \$1433 vn VSS nfet_03v3 L=0.28U W=1U AS=0.75P AD=0.75P PS=3.5U PD=3.5U
M$275 vn \$1433 \$1454 VSS nfet_03v3 L=0.28U W=2U AS=1.5P AD=1.5P PS=5.5U
+ PD=5.5U
M$276 vn \$1434 vn VSS nfet_03v3 L=0.28U W=1U AS=0.75P AD=0.75P PS=3.5U PD=3.5U
M$277 vp \$1434 \$1454 VSS nfet_03v3 L=0.28U W=2U AS=1.5P AD=1.5P PS=5.5U
+ PD=5.5U
M$278 vp \$1433 vp VSS nfet_03v3 L=0.28U W=1U AS=0.75P AD=0.75P PS=3.5U PD=3.5U
M$279 VSS VSS VSS VSS nfet_03v3 L=2U W=32U AS=18.56P AD=18.56P PS=80.24U
+ PD=80.24U
M$281 \$1457 IB VSS VSS nfet_03v3 L=2U W=3.2U AS=1.92P AD=1.92P PS=7.6U PD=7.6U
M$282 \$1750 \$1454 \$1749 VSS nfet_03v3 L=2U W=1.6U AS=0.96P AD=0.96P PS=4.4U
+ PD=4.4U
M$283 \$1749 IB VSS VSS nfet_03v3 L=2U W=3.2U AS=1.92P AD=1.92P PS=7.6U PD=7.6U
M$284 \$1764 Vcm \$1749 VSS nfet_03v3 L=2U W=1.6U AS=0.96P AD=0.96P PS=4.4U
+ PD=4.4U
M$288 \$1750 \$1453 \$1457 VSS nfet_03v3 L=2U W=1.6U AS=0.96P AD=0.96P PS=4.4U
+ PD=4.4U
M$289 \$1764 Vcm \$1457 VSS nfet_03v3 L=2U W=1.6U AS=0.96P AD=0.96P PS=4.4U
+ PD=4.4U
M$291 \$1753 \$1433 \$1452 VSS nfet_03v3 L=0.28U W=2U AS=1.5P AD=1.5P PS=5.5U
+ PD=5.5U
M$292 \$1753 \$1434 \$1753 VSS nfet_03v3 L=0.28U W=1U AS=0.75P AD=0.75P PS=3.5U
+ PD=3.5U
M$293 \$1754 \$1434 \$1452 VSS nfet_03v3 L=0.28U W=2U AS=1.5P AD=1.5P PS=5.5U
+ PD=5.5U
M$294 \$1754 \$1433 \$1754 VSS nfet_03v3 L=0.28U W=1U AS=0.75P AD=0.75P PS=3.5U
+ PD=3.5U
M$295 \$1754 \$1433 \$1451 VSS nfet_03v3 L=0.28U W=2U AS=1.5P AD=1.5P PS=5.5U
+ PD=5.5U
M$296 \$1754 \$1434 \$1754 VSS nfet_03v3 L=0.28U W=1U AS=0.75P AD=0.75P PS=3.5U
+ PD=3.5U
M$297 \$1753 \$1434 \$1451 VSS nfet_03v3 L=0.28U W=2U AS=1.5P AD=1.5P PS=5.5U
+ PD=5.5U
M$298 \$1753 \$1433 \$1753 VSS nfet_03v3 L=0.28U W=1U AS=0.75P AD=0.75P PS=3.5U
+ PD=3.5U
M$299 \$1956 CLK VSS VSS nfet_03v3 L=0.28U W=1U AS=0.75P AD=0.75P PS=3.5U
+ PD=3.5U
M$300 \$1958 CLK \$1957 VSS nfet_03v3 L=0.28U W=2U AS=1.5P AD=1.5P PS=5.5U
+ PD=5.5U
M$301 \$1957 \$1964 VSS VSS nfet_03v3 L=0.28U W=2U AS=1.5P AD=1.5P PS=5.5U
+ PD=5.5U
M$302 \$1959 \$1958 VSS VSS nfet_03v3 L=0.28U W=1U AS=0.75P AD=0.75P PS=3.5U
+ PD=3.5U
M$303 \$1960 \$1959 VSS VSS nfet_03v3 L=0.28U W=1U AS=0.75P AD=0.75P PS=3.5U
+ PD=3.5U
M$304 \$1433 \$1960 VSS VSS nfet_03v3 L=0.28U W=1U AS=0.75P AD=0.75P PS=3.5U
+ PD=3.5U
M$305 \$1962 \$1960 \$1961 VSS nfet_03v3 L=0.28U W=2U AS=1.5P AD=1.5P PS=5.5U
+ PD=5.5U
M$306 \$1961 \$1956 VSS VSS nfet_03v3 L=0.28U W=2U AS=1.5P AD=1.5P PS=5.5U
+ PD=5.5U
M$307 \$1963 \$1962 VSS VSS nfet_03v3 L=0.28U W=1U AS=0.75P AD=0.75P PS=3.5U
+ PD=3.5U
M$308 \$1964 \$1963 VSS VSS nfet_03v3 L=0.28U W=1U AS=0.75P AD=0.75P PS=3.5U
+ PD=3.5U
M$309 \$1434 \$1964 VSS VSS nfet_03v3 L=0.28U W=1U AS=0.75P AD=0.75P PS=3.5U
+ PD=3.5U
M$312 \$3306 \$3306 VSS VSS nfet_03v3 L=6U W=1.8U AS=1.08P AD=1.08P PS=4.8U
+ PD=4.8U
M$313 \$3997 \$3988 VSS VSS nfet_03v3 L=6U W=1.8U AS=1.08P AD=1.08P PS=4.8U
+ PD=4.8U
M$314 \$4301 \$3306 VSS VSS nfet_03v3 L=6U W=1.8U AS=1.08P AD=1.08P PS=4.8U
+ PD=4.8U
M$315 \$4309 \$3988 VSS VSS nfet_03v3 L=6U W=1.8U AS=1.08P AD=1.08P PS=4.8U
+ PD=4.8U
M$316 \$3996 \$3306 VSS VSS nfet_03v3 L=6U W=1.8U AS=1.08P AD=1.08P PS=4.8U
+ PD=4.8U
M$317 \$3988 \$3988 VSS VSS nfet_03v3 L=6U W=1.8U AS=1.08P AD=1.08P PS=4.8U
+ PD=4.8U
M$321 IB IB VSS VSS nfet_03v3 L=2U W=3.2U AS=1.92P AD=1.92P PS=7.6U PD=7.6U
M$323 \$3245 \$1433 \$3996 VSS nfet_03v3 L=0.28U W=2U AS=1.5P AD=1.5P PS=5.5U
+ PD=5.5U
M$324 \$3245 \$1434 \$3245 VSS nfet_03v3 L=0.28U W=1U AS=0.75P AD=0.75P PS=3.5U
+ PD=3.5U
M$325 \$2514 \$1434 \$3996 VSS nfet_03v3 L=0.28U W=2U AS=1.5P AD=1.5P PS=5.5U
+ PD=5.5U
M$326 \$2514 \$1433 \$2514 VSS nfet_03v3 L=0.28U W=1U AS=0.75P AD=0.75P PS=3.5U
+ PD=3.5U
M$327 \$2514 \$1433 \$3997 VSS nfet_03v3 L=0.28U W=2U AS=1.5P AD=1.5P PS=5.5U
+ PD=5.5U
M$328 \$2514 \$1434 \$2514 VSS nfet_03v3 L=0.28U W=1U AS=0.75P AD=0.75P PS=3.5U
+ PD=3.5U
M$329 \$3245 \$1434 \$3997 VSS nfet_03v3 L=0.28U W=2U AS=1.5P AD=1.5P PS=5.5U
+ PD=5.5U
M$330 \$3245 \$1433 \$3245 VSS nfet_03v3 L=0.28U W=1U AS=0.75P AD=0.75P PS=3.5U
+ PD=3.5U
M$333 \$4000 IB VSS VSS nfet_03v3 L=2U W=3.2U AS=1.92P AD=1.92P PS=7.6U PD=7.6U
M$334 \$4292 \$3997 \$4291 VSS nfet_03v3 L=2U W=1.6U AS=0.96P AD=0.96P PS=4.4U
+ PD=4.4U
M$335 \$4291 IB VSS VSS nfet_03v3 L=2U W=3.2U AS=1.92P AD=1.92P PS=7.6U PD=7.6U
M$336 \$4306 Vcm \$4291 VSS nfet_03v3 L=2U W=1.6U AS=0.96P AD=0.96P PS=4.4U
+ PD=4.4U
M$340 \$4292 \$3996 \$4000 VSS nfet_03v3 L=2U W=1.6U AS=0.96P AD=0.96P PS=4.4U
+ PD=4.4U
M$341 \$4306 Vcm \$4000 VSS nfet_03v3 L=2U W=1.6U AS=0.96P AD=0.96P PS=4.4U
+ PD=4.4U
M$343 \$4295 \$1433 \$3995 VSS nfet_03v3 L=0.28U W=2U AS=1.5P AD=1.5P PS=5.5U
+ PD=5.5U
M$344 \$4295 \$1434 \$4295 VSS nfet_03v3 L=0.28U W=1U AS=0.75P AD=0.75P PS=3.5U
+ PD=3.5U
M$345 \$4296 \$1434 \$3995 VSS nfet_03v3 L=0.28U W=2U AS=1.5P AD=1.5P PS=5.5U
+ PD=5.5U
M$346 \$4296 \$1433 \$4296 VSS nfet_03v3 L=0.28U W=1U AS=0.75P AD=0.75P PS=3.5U
+ PD=3.5U
M$347 \$4296 \$1433 \$3994 VSS nfet_03v3 L=0.28U W=2U AS=1.5P AD=1.5P PS=5.5U
+ PD=5.5U
M$348 \$4296 \$1434 \$4296 VSS nfet_03v3 L=0.28U W=1U AS=0.75P AD=0.75P PS=3.5U
+ PD=3.5U
M$349 \$4295 \$1434 \$3994 VSS nfet_03v3 L=0.28U W=2U AS=1.5P AD=1.5P PS=5.5U
+ PD=5.5U
M$350 \$4295 \$1433 \$4295 VSS nfet_03v3 L=0.28U W=1U AS=0.75P AD=0.75P PS=3.5U
+ PD=3.5U
M$351 \$1122 VG VG VG nfet_03v3 L=5U W=0.5U AS=0.3P AD=0.3P PS=2.2U PD=2.2U
M$352 vn \$940 \$940 \$940 nfet_03v3 L=12U W=0.5U AS=0.3P AD=0.3P PS=2.2U
+ PD=2.2U
M$353 \$1451 VG VG VG nfet_03v3 L=5U W=0.5U AS=0.3P AD=0.3P PS=2.2U PD=2.2U
M$354 \$1122 \$940 \$940 \$940 nfet_03v3 L=12U W=0.5U AS=0.3P AD=0.3P PS=2.2U
+ PD=2.2U
M$355 \$1752 VG VG VG nfet_03v3 L=5U W=0.5U AS=0.3P AD=0.3P PS=2.2U PD=2.2U
M$356 vp \$1751 \$1751 \$1751 nfet_03v3 L=12U W=0.5U AS=0.3P AD=0.3P PS=2.2U
+ PD=2.2U
M$357 \$1452 VG VG VG nfet_03v3 L=5U W=0.5U AS=0.3P AD=0.3P PS=2.2U PD=2.2U
M$358 \$1752 \$1751 \$1751 \$1751 nfet_03v3 L=12U W=0.5U AS=0.3P AD=0.3P
+ PS=2.2U PD=2.2U
M$359 \$3669 VG VG VG nfet_03v3 L=5U W=0.5U AS=0.3P AD=0.3P PS=2.2U PD=2.2U
M$360 \$2514 \$3487 \$3487 \$3487 nfet_03v3 L=12U W=0.5U AS=0.3P AD=0.3P
+ PS=2.2U PD=2.2U
M$361 \$3994 VG VG VG nfet_03v3 L=5U W=0.5U AS=0.3P AD=0.3P PS=2.2U PD=2.2U
M$362 \$3669 \$3487 \$3487 \$3487 nfet_03v3 L=12U W=0.5U AS=0.3P AD=0.3P
+ PS=2.2U PD=2.2U
M$363 \$4294 VG VG VG nfet_03v3 L=5U W=0.5U AS=0.3P AD=0.3P PS=2.2U PD=2.2U
M$364 \$3245 \$4293 \$4293 \$4293 nfet_03v3 L=12U W=0.5U AS=0.3P AD=0.3P
+ PS=2.2U PD=2.2U
M$365 \$3995 VG VG VG nfet_03v3 L=5U W=0.5U AS=0.3P AD=0.3P PS=2.2U PD=2.2U
M$366 \$4294 \$4293 \$4293 \$4293 nfet_03v3 L=12U W=0.5U AS=0.3P AD=0.3P
+ PS=2.2U PD=2.2U
C$367 \$2514 \$3245 1e-12 cap_mim_2f0fF A=500P P=200U
C$368 \$3994 VINN 4e-12 cap_mim_2f0fF A=2000P P=400U
C$369 vp \$1452 2e-13 cap_mim_2f0fF A=100P P=40U
C$370 vn vp 1e-12 cap_mim_2f0fF A=500P P=200U
C$371 vn \$1451 2e-13 cap_mim_2f0fF A=100P P=40U
C$374 \$1452 \$3245 1e-12 cap_mim_2f0fF A=500P P=200U
C$375 \$3245 \$3995 2e-13 cap_mim_2f0fF A=100P P=40U
C$377 \$3995 VINP 4e-12 cap_mim_2f0fF A=2000P P=400U
C$378 \$1451 \$2514 1e-12 cap_mim_2f0fF A=500P P=200U
C$384 \$2514 \$3994 2e-13 cap_mim_2f0fF A=100P P=40U
C$401 VSS VSS 4.84e-13 cap_mim_2f0fF A=242P P=88U
C$403 outn \$65 2.42e-13 cap_mim_2f0fF A=121P P=44U
C$404 outp \$72 2.42e-13 cap_mim_2f0fF A=121P P=44U
C$405 outp \$73 9.68e-13 cap_mim_2f0fF A=484P P=176U
C$406 outp \$44 1.936e-12 cap_mim_2f0fF A=968P P=352U
C$411 outp \$58 4.84e-13 cap_mim_2f0fF A=242P P=88U
C$413 vn inn 3.872e-12 cap_mim_2f0fF A=1936P P=704U
M$422 VSS VSS VSS VSS nfet_03v3 L=0.36U W=103.2U AS=59.856P AD=59.856P
+ PS=262.08U PD=262.08U
M$423 \$44 swm8 inn VSS nfet_03v3 L=0.36U W=1.3U AS=0.78P AD=0.78P PS=3.8U
+ PD=3.8U
M$426 \$72 swm1 inn VSS nfet_03v3 L=0.36U W=1.3U AS=0.78P AD=0.78P PS=3.8U
+ PD=3.8U
M$429 \$58 swm2 inn VSS nfet_03v3 L=0.36U W=1.3U AS=0.78P AD=0.78P PS=3.8U
+ PD=3.8U
M$432 outp sw0 inn VSS nfet_03v3 L=0.36U W=1.3U AS=0.78P AD=0.78P PS=3.8U
+ PD=3.8U
M$435 \$73 swm4 inn VSS nfet_03v3 L=0.36U W=1.3U AS=0.78P AD=0.78P PS=3.8U
+ PD=3.8U
M$438 \$421 swm16 inn VSS nfet_03v3 L=0.36U W=1.3U AS=0.78P AD=0.78P PS=3.8U
+ PD=3.8U
C$445 outn \$35 1.936e-12 cap_mim_2f0fF A=968P P=352U
C$451 outn \$53 4.84e-13 cap_mim_2f0fF A=242P P=88U
C$456 outn \$63 9.68e-13 cap_mim_2f0fF A=484P P=176U
M$463 \$35 swm8 inp VSS nfet_03v3 L=0.36U W=1.3U AS=0.78P AD=0.78P PS=3.8U
+ PD=3.8U
M$466 \$65 swm1 inp VSS nfet_03v3 L=0.36U W=1.3U AS=0.78P AD=0.78P PS=3.8U
+ PD=3.8U
M$469 \$53 swm2 inp VSS nfet_03v3 L=0.36U W=1.3U AS=0.78P AD=0.78P PS=3.8U
+ PD=3.8U
M$472 outn sw0 inp VSS nfet_03v3 L=0.36U W=1.3U AS=0.78P AD=0.78P PS=3.8U
+ PD=3.8U
M$475 \$410 swm16 inp VSS nfet_03v3 L=0.36U W=1.3U AS=0.78P AD=0.78P PS=3.8U
+ PD=3.8U
M$478 \$63 swm4 inp VSS nfet_03v3 L=0.36U W=1.3U AS=0.78P AD=0.78P PS=3.8U
+ PD=3.8U
C$485 vp inp 3.872e-12 cap_mim_2f0fF A=1936P P=704U
C$487 outn \$410 3.872e-12 cap_mim_2f0fF A=1936P P=704U
M$490 VDD3V3 VDD3V3 VDD3V3 VDD3V3 pfet_03v3 L=0.36U W=252U AS=146.16P
+ AD=146.16P PS=559.68U PD=559.68U
C$533 outp \$421 3.872e-12 cap_mim_2f0fF A=1936P P=704U
M$582 outn \$451 inp VDD3V3 pfet_03v3 L=0.36U W=4.5U AS=2.7P AD=2.7P PS=10.2U
+ PD=10.2U
M$585 \$35 \$195 inp VDD3V3 pfet_03v3 L=0.36U W=4.5U AS=2.7P AD=2.7P PS=10.2U
+ PD=10.2U
M$588 \$65 \$210 inp VDD3V3 pfet_03v3 L=0.36U W=4.5U AS=2.7P AD=2.7P PS=10.2U
+ PD=10.2U
M$591 \$63 \$450 inp VDD3V3 pfet_03v3 L=0.36U W=4.5U AS=2.7P AD=2.7P PS=10.2U
+ PD=10.2U
M$594 \$410 \$449 inp VDD3V3 pfet_03v3 L=0.36U W=4.5U AS=2.7P AD=2.7P PS=10.2U
+ PD=10.2U
M$597 \$53 \$223 inp VDD3V3 pfet_03v3 L=0.36U W=4.5U AS=2.7P AD=2.7P PS=10.2U
+ PD=10.2U
M$600 outp \$445 inn VDD3V3 pfet_03v3 L=0.36U W=4.5U AS=2.7P AD=2.7P PS=10.2U
+ PD=10.2U
M$603 \$73 \$446 inn VDD3V3 pfet_03v3 L=0.36U W=4.5U AS=2.7P AD=2.7P PS=10.2U
+ PD=10.2U
M$606 \$44 \$190 inn VDD3V3 pfet_03v3 L=0.36U W=4.5U AS=2.7P AD=2.7P PS=10.2U
+ PD=10.2U
M$609 \$72 \$206 inn VDD3V3 pfet_03v3 L=0.36U W=4.5U AS=2.7P AD=2.7P PS=10.2U
+ PD=10.2U
M$612 \$421 \$447 inn VDD3V3 pfet_03v3 L=0.36U W=4.5U AS=2.7P AD=2.7P PS=10.2U
+ PD=10.2U
M$615 \$58 \$228 inn VDD3V3 pfet_03v3 L=0.36U W=4.5U AS=2.7P AD=2.7P PS=10.2U
+ PD=10.2U
.ENDS top_int
