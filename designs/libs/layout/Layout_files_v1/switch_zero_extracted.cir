* Extracted by KLayout with GF180MCU LVS runset on : 23/08/2026 17:06

.SUBCKT switch_zero VDD3V3 gf180mcu_gnd clk clkb in out
M$1 clkb clk VDD3V3 VDD3V3 pfet_03v3 L=0.36U W=12U AS=5.28P AD=5.28P PS=19.76U
+ PD=19.76U
M$3 clkb clk gf180mcu_gnd gf180mcu_gnd nfet_03v3 L=0.36U W=6U AS=2.64P AD=2.64P
+ PS=10.76U PD=10.76U
M$5 gf180mcu_gnd gf180mcu_gnd gf180mcu_gnd gf180mcu_gnd nfet_03v3 L=0.36U
+ W=8.6U AS=4.988P AD=4.988P PS=21.84U PD=21.84U
M$6 out clk in gf180mcu_gnd nfet_03v3 L=0.36U W=1.3U AS=0.78P AD=0.78P PS=3.8U
+ PD=3.8U
M$8 VDD3V3 VDD3V3 VDD3V3 VDD3V3 pfet_03v3 L=0.36U W=21U AS=12.18P AD=12.18P
+ PS=46.64U PD=46.64U
M$9 out clkb in VDD3V3 pfet_03v3 L=0.36U W=4.5U AS=2.7P AD=2.7P PS=10.2U
+ PD=10.2U
.ENDS switch_zero
