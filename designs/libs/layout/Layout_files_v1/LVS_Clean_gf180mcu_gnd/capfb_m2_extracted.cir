* Extracted by KLayout with GF180MCU LVS runset on : 24/08/2026 01:05

.SUBCKT capfb_m2 in clk VDD3V3 out VSS
M$1 \$17 clk VDD3V3 VDD3V3 pfet_03v3 L=0.36U W=12U AS=5.28P AD=5.28P PS=19.76U
+ PD=19.76U
M$3 \$17 clk VSS VSS nfet_03v3 L=0.36U W=6U AS=2.64P AD=2.64P PS=10.76U
+ PD=10.76U
C$5 out \$9 4.84e-13 cap_mim_2f0fF A=242P P=88U
M$7 VSS VSS VSS VSS nfet_03v3 L=0.36U W=8.6U AS=4.988P AD=4.988P PS=21.84U
+ PD=21.84U
M$8 \$9 clk in VSS nfet_03v3 L=0.36U W=1.3U AS=0.78P AD=0.78P PS=3.8U PD=3.8U
M$10 VDD3V3 VDD3V3 VDD3V3 VDD3V3 pfet_03v3 L=0.36U W=21U AS=12.18P AD=12.18P
+ PS=46.64U PD=46.64U
M$11 \$9 \$17 in VDD3V3 pfet_03v3 L=0.36U W=4.5U AS=2.7P AD=2.7P PS=10.2U
+ PD=10.2U
.ENDS capfb_m2
