** sch_path: /foss/designs/core_pga/switch/switch.sch
.subckt switch VDD3V3 gf180mcu_gnd in out clk clkb
*.PININFO gf180mcu_gnd:B VDD3V3:B clk:I clkb:I in:B out:B
M5 in clkb out VDD3V3 pfet_03v3 L=0.36u W=4.5u nf=1
M7 out clk in gf180mcu_gnd nfet_03v3 L=0.36u W=1.3u nf=1
M1 VDD3V3 VDD3V3 VDD3V3 VDD3V3 pfet_03v3 L=0.36u W=4.5u nf=1 m=2
M2 gf180mcu_gnd gf180mcu_gnd gf180mcu_gnd gf180mcu_gnd nfet_03v3 L=0.36u W=1.3u nf=1 m=2
.ends
