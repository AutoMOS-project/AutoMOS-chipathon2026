* Extracted by KLayout with GF180MCU LVS runset on : 23/08/2026 05:01

.SUBCKT folded_cascode_v3 gf180mcu_gnd Vcm VDD3V3 1ua Vb0V94 outn outp Vb1V3
+ inn inp
M$1 \$63 \$18 VDD3V3 VDD3V3 pfet_03v3 L=1U W=32U AS=19.2P AD=19.2P PS=65.2U
+ PD=65.2U
M$2 VDD3V3 \$10 \$56 VDD3V3 pfet_03v3 L=1U W=4U AS=2.4P AD=2.4P PS=9.2U PD=9.2U
M$3 \$38 inn \$63 VDD3V3 pfet_03v3 L=1U W=10U AS=6P AD=6P PS=21.2U PD=21.2U
M$4 \$36 inp \$63 VDD3V3 pfet_03v3 L=1U W=10U AS=6P AD=6P PS=21.2U PD=21.2U
M$5 outp Vb1V3 \$56 VDD3V3 pfet_03v3 L=1U W=4U AS=2.4P AD=2.4P PS=9.2U PD=9.2U
M$6 \$55 \$10 VDD3V3 VDD3V3 pfet_03v3 L=1U W=4U AS=2.4P AD=2.4P PS=9.2U PD=9.2U
M$7 \$55 Vb1V3 outn VDD3V3 pfet_03v3 L=1U W=4U AS=2.4P AD=2.4P PS=9.2U PD=9.2U
M$8 \$34 \$18 VDD3V3 VDD3V3 pfet_03v3 L=1U W=11U AS=6.6P AD=6.6P PS=23.2U
+ PD=23.2U
M$9 \$10 \$10 VDD3V3 VDD3V3 pfet_03v3 L=1U W=3U AS=1.8P AD=1.8P PS=7.2U PD=7.2U
M$10 \$9 \$9 VDD3V3 VDD3V3 pfet_03v3 L=1U W=3U AS=1.8P AD=1.8P PS=7.2U PD=7.2U
M$11 \$4 \$18 VDD3V3 VDD3V3 pfet_03v3 L=1U W=4.9U AS=2.94P AD=2.94P PS=11U
+ PD=11U
M$12 \$12 \$12 VDD3V3 VDD3V3 pfet_03v3 L=1U W=3U AS=1.8P AD=1.8P PS=7.2U PD=7.2U
M$13 \$18 \$18 VDD3V3 VDD3V3 pfet_03v3 L=1U W=6U AS=3.6P AD=3.6P PS=13.2U
+ PD=13.2U
M$14 outp Vb0V94 \$38 gf180mcu_gnd nfet_03v3 L=1U W=4U AS=2.4P AD=2.4P PS=9.2U
+ PD=9.2U
M$15 \$36 Vb0V94 outn gf180mcu_gnd nfet_03v3 L=1U W=4U AS=2.4P AD=2.4P PS=9.2U
+ PD=9.2U
M$16 \$34 \$34 gf180mcu_gnd gf180mcu_gnd nfet_03v3 L=1U W=4U AS=2.4P AD=2.4P
+ PS=9.2U PD=9.2U
M$17 \$36 \$34 gf180mcu_gnd gf180mcu_gnd nfet_03v3 L=1U W=9U AS=5.4P AD=5.4P
+ PS=19.2U PD=19.2U
M$18 1ua 1ua gf180mcu_gnd gf180mcu_gnd nfet_03v3 L=1U W=1U AS=0.6P AD=0.6P
+ PS=3.2U PD=3.2U
M$19 \$18 1ua gf180mcu_gnd gf180mcu_gnd nfet_03v3 L=1U W=3U AS=1.8P AD=1.8P
+ PS=7.2U PD=7.2U
M$20 \$12 outn \$11 gf180mcu_gnd nfet_03v3 L=1U W=10U AS=6P AD=6P PS=21.2U
+ PD=21.2U
M$21 \$3 \$4 gf180mcu_gnd gf180mcu_gnd nfet_03v3 L=1U W=8U AS=4.8P AD=4.8P
+ PS=17.2U PD=17.2U
M$22 \$9 outp \$3 gf180mcu_gnd nfet_03v3 L=1U W=10U AS=6P AD=6P PS=21.2U
+ PD=21.2U
M$23 \$4 \$4 gf180mcu_gnd gf180mcu_gnd nfet_03v3 L=1U W=8U AS=4.8P AD=4.8P
+ PS=17.2U PD=17.2U
M$24 gf180mcu_gnd \$34 \$38 gf180mcu_gnd nfet_03v3 L=1U W=9U AS=5.4P AD=5.4P
+ PS=19.2U PD=19.2U
M$25 \$11 \$4 gf180mcu_gnd gf180mcu_gnd nfet_03v3 L=1U W=8U AS=4.8P AD=4.8P
+ PS=17.2U PD=17.2U
M$26 \$10 Vcm \$11 gf180mcu_gnd nfet_03v3 L=1U W=10U AS=6P AD=6P PS=21.2U
+ PD=21.2U
M$27 \$10 Vcm \$3 gf180mcu_gnd nfet_03v3 L=1U W=10U AS=6P AD=6P PS=21.2U
+ PD=21.2U
.ENDS folded_cascode_v3
